$ Spice netlist generated by v2lvs
$ v2024.3_25.13    Thu Aug 1 18:56:55 PDT 2024
.INCLUDE "/courses/ee6350/pdk2025/tcbn65gplus/TSMCHOME/digital/Back_End/spice/tcbn65gplus_200a/tcbn65gplus_200a.spi"
*.BUSDELIMITER [

.SUBCKT csa3_WIDTH29_1 input_a[28] input_a[27] input_a[26] input_a[25]
+ input_a[24] input_a[23] input_a[22] input_a[21] input_a[20] input_a[19]
+ input_a[18] input_a[17] input_a[16] input_a[15] input_a[14] input_a[13]
+ input_a[12] input_a[11] input_a[10] input_a[9] input_a[8] input_a[7]
+ input_a[6] input_a[5] input_a[4] input_a[3] input_a[2] input_a[1] input_a[0]
+ input_b[28] input_b[27] input_b[26] input_b[25] input_b[24] input_b[23]
+ input_b[22] input_b[21] input_b[20] input_b[19] input_b[18] input_b[17]
+ input_b[16] input_b[15] input_b[14] input_b[13] input_b[12] input_b[11]
+ input_b[10] input_b[9] input_b[8] input_b[7] input_b[6] input_b[5] input_b[4]
+ input_b[3] input_b[2] input_b[1] input_b[0] input_c[28] input_c[27]
+ input_c[26] input_c[25] input_c[24] input_c[23] input_c[22] input_c[21]
+ input_c[20] input_c[19] input_c[18] input_c[17] input_c[16] input_c[15]
+ input_c[14] input_c[13] input_c[12] input_c[11] input_c[10] input_c[9]
+ input_c[8] input_c[7] input_c[6] input_c[5] input_c[4] input_c[3] input_c[2]
+ input_c[1] input_c[0] sum[28] sum[27] sum[26] sum[25] sum[24] sum[23] sum[22]
+ sum[21] sum[20] sum[19] sum[18] sum[17] sum[16] sum[15] sum[14] sum[13]
+ sum[12] sum[11] sum[10] sum[9] sum[8] sum[7] sum[6] sum[5] sum[4] sum[3]
+ sum[2] sum[1] sum[0] carry[28] carry[27] carry[26] carry[25] carry[24]
+ carry[23] carry[22] carry[21] carry[20] carry[19] carry[18] carry[17]
+ carry[16] carry[15] carry[14] carry[13] carry[12] carry[11] carry[10]
+ carry[9] carry[8] carry[7] carry[6] carry[5] carry[4] carry[3] carry[2]
+ carry[1] carry[0] VDD VSS
XFE_PSC1657_base_plane_13 input_a[13] FE_PSN1657_base_plane_13 VDD VSS CKBD4
XFE_PSC1637_n2331 input_c[16] FE_PSN1637_n2331 VDD VSS BUFFD4
XFE_OCPC1574_base_plane_20 input_a[20] FE_OCPN1574_base_plane_20 VDD VSS BUFFD4
XFE_OCPC1528_base_plane_11 input_a[11] FE_OCPN1528_base_plane_11 VDD VSS BUFFD4
XFE_OCPC1516_n2317 input_c[1] FE_OCPN1516_n2317 VDD VSS CKBD4
XFE_OCPC1486_n3854 input_c[17] FE_OCPN1486_n3854 VDD VSS CKBD1
XFE_OCPC1454_base_plane_8 input_a[8] FE_OCPN1454_base_plane_8 VDD VSS BUFFD4
XFE_OCPC1447_base_plane_12 input_a[12] FE_OCPN1447_base_plane_12 VDD VSS BUFFD2
XFE_OCPC1425_base_plane_17 input_a[17] FE_OCPN1425_base_plane_17 VDD VSS BUFFD4
XFE_OCPC1416_base_plane_12 input_a[12] FE_OCPN1416_base_plane_12 VDD VSS CKBD1
XFE_RC_1692_0 input_b[5] n44 VDD VSS CKND4
XFE_RC_1677_0 input_b[21] n73 FE_RN_562_0 VDD VSS IND2D2
XFE_RC_1637_0 input_b[4] n28 VDD VSS CKND2
XFE_RC_1636_0 input_c[9] n64 VDD VSS INVD2
XFE_RC_1518_0 input_b[7] n30 VDD VSS INVD2
XFE_OCPC1408_base_plane_8 FE_OCPN1454_base_plane_8 FE_OCPN1408_base_plane_8 VDD
+ VSS BUFFD4
XFE_OFC1377_n3854_dup input_c[17] FE_RN_6 VDD VSS BUFFD4
XFE_RC_1413_0 FE_OFN1341_base_plane_17 FE_OFN1340_selected_delta_1_17
+ FE_OFN1377_n3854 FE_RN_709_0 VDD VSS INR3D4
XFE_RC_1409_0 FE_RN_4 FE_RN_1 FE_RN_5 FE_RN_430_0 VDD VSS ND3D3
XFE_OFC1339_n3865_dup input_b[16] FE_RN_5 VDD VSS BUFFD4
XFE_OFC1342_base_plane_16_dup input_a[16] FE_RN_4 VDD VSS CKBD4
XFE_OFC1341_base_plane_17_dup input_a[17] FE_RN_3 VDD VSS BUFFD4
XFE_OFC1340_selected_delta_1_17_dup input_b[17] FE_RN_2 VDD VSS BUFFD4
XFE_OFC1371_n2331_dup input_c[16] FE_RN_1 VDD VSS BUFFD4
XFE_OFC1377_n3854 input_c[17] FE_OFN1377_n3854 VDD VSS BUFFD4
XFE_OFC1342_base_plane_16 input_a[16] FE_OFN1342_base_plane_16 VDD VSS BUFFD8
XFE_OFC1341_base_plane_17 input_a[17] FE_OFN1341_base_plane_17 VDD VSS BUFFD4
XFE_OFC1340_selected_delta_1_17 input_b[17] FE_OFN1340_selected_delta_1_17 VDD
+ VSS BUFFD4
XFE_OFC1339_n3865 input_b[16] FE_OFN1339_n3865 VDD VSS BUFFD4
XFE_RC_1325_0 FE_RN_2 FE_RN_3 FE_OCPN1486_n3854 n69 VDD VSS OAI21D4
XFE_RC_1310_0 n82 n83 n81 carry[15] VDD VSS AOI21D4
XFE_OCPC1332_n3842 input_b[14] FE_OCPN1332_n3842 VDD VSS BUFFD4
XFE_RC_1271_0 input_b[17] FE_RN_704_0 VDD VSS INVD2
XFE_RC_1270_0 input_a[17] FE_RN_6 FE_RN_704_0 FE_RN_705_0 VDD VSS IND3D2
XFE_RC_1269_0 input_c[17] input_b[17] FE_RN_3 FE_RN_706_0 VDD VSS ND3D3
XFE_RC_1268_0 FE_OFN1377_n3854 FE_OCPN1425_base_plane_17 FE_RN_707_0 VDD VSS
+ NR2D2
XFE_RC_1267_0 FE_RN_707_0 FE_RN_2 FE_RN_708_0 VDD VSS ND2D3
XFE_RC_1265_0 FE_RN_709_0 FE_RN_708_0 FE_RN_706_0 FE_RN_705_0 sum[17] VDD VSS
+ IND4D4
XFE_OCPC1323_base_plane_12 FE_OCPN1447_base_plane_12 FE_OCPN1323_base_plane_12
+ VDD VSS BUFFD2
XFE_OCPC1322_n2362 input_b[21] FE_OCPN1322_n2362 VDD VSS BUFFD2
XFE_RC_1154_0 n85 n86 n84 carry[7] VDD VSS AOI21D4
XFE_RC_1145_0 input_c[28] FE_RN_642_0 VDD VSS CKND2
XFE_RC_1144_0 input_b[27] FE_RN_642_0 FE_RN_643_0 VDD VSS ND2D2
XFE_RC_1143_0 input_c[28] FE_RN_644_0 VDD VSS CKND2
XFE_RC_1142_0 input_b[27] FE_RN_644_0 FE_RN_643_0 sum[27] VDD VSS OAI21D4
XFE_RC_1002_0 FE_RN_562_0 input_c[21] n87 VDD VSS CKND2D2
XFE_RC_858_0 n40 n22 n39 carry[19] VDD VSS AOI21D4
XFE_RC_814_0 FE_OFN1342_base_plane_16 FE_RN_1 FE_RN_431_0 FE_RN_432_0 VDD VSS
+ IND3D4
XFE_RC_781_0 input_b[16] FE_RN_431_0 VDD VSS INVD3
XFE_RC_779_0 FE_PSN1637_n2331 FE_OFN1339_n3865 FE_RN_433_0 VDD VSS NR2D3
XFE_RC_778_0 FE_RN_433_0 FE_OFN1342_base_plane_16 FE_RN_434_0 VDD VSS ND2D4
XFE_RC_777_0 input_b[16] FE_RN_435_0 VDD VSS CKND3
XFE_RC_776_0 FE_PSN1637_n2331 FE_RN_435_0 FE_OFN1342_base_plane_16 FE_RN_436_0
+ VDD VSS NR3D2
XFE_RC_775_0 FE_RN_436_0 FE_RN_434_0 FE_RN_432_0 FE_RN_430_0 sum[16] VDD VSS
+ IND4D4
XFE_RC_658_0 FE_OCPN1271_n3856 FE_OCPN1323_base_plane_12 FE_RN_369_0 VDD VSS
+ CKND2D2
XFE_RC_657_0 FE_RN_369_0 n19 carry[13] VDD VSS ND2D3
XFE_RC_639_0 n60 n61 FE_RN_356_0 VDD VSS ND2D2
XFE_RC_638_0 input_c[1] FE_RN_356_0 n94 VDD VSS CKND2D2
XFE_RC_627_0 input_b[20] FE_OCPN1574_base_plane_20 input_c[20] n88 VDD VSS
+ OAI21D4
XFE_OCPC1271_n3856 input_b[12] FE_OCPN1271_n3856 VDD VSS BUFFD2
XFE_OCPC1244_base_plane_10 input_a[10] FE_OCPN1244_base_plane_10 VDD VSS BUFFD4
XFE_OCPC1241_n2347 input_b[8] FE_OCPN1241_n2347 VDD VSS BUFFD4
XFE_RC_433_0 FE_OCPN1516_n2317 n93 FE_RN_234_0 VDD VSS IND2D4
XFE_RC_432_0 n93 FE_RN_235_0 VDD VSS CKND2
XFE_RC_431_0 FE_RN_235_0 FE_OCPN1516_n2317 FE_RN_236_0 VDD VSS CKND2D3
XFE_RC_430_0 FE_RN_236_0 FE_RN_234_0 sum[1] VDD VSS ND2D4
XFE_RC_304_0 input_b[11] input_a[11] input_c[11] n74 VDD VSS OAI21D4
XFE_RC_260_0 input_a[21] input_b[21] n17 sum[21] VDD VSS XNR3D4
XFE_RC_176_0 input_b[11] FE_OCPN1528_base_plane_11 FE_RN_94_0 VDD VSS CKND2D3
XFE_RC_175_0 n74 FE_RN_94_0 carry[12] VDD VSS ND2D4
XFE_OCPC1224_base_plane_3 input_a[3] FE_OCPN1224_base_plane_3 VDD VSS CKBD0
XFE_OCPC1210_n3855 input_b[10] FE_OCPN1210_n3855 VDD VSS BUFFD4
XFE_OCPC1200_base_plane_4 input_a[4] FE_OCPN1200_base_plane_4 VDD VSS CKBD1
XFE_OFC934_base_plane_13 input_a[13] n41 VDD VSS CKND4
XFE_OFC874_base_plane_2 input_a[2] n35 VDD VSS CKND2
XFE_OFC806_n2020 input_b[13] n42 VDD VSS CKND4
XFE_OFC725_base_plane_16 input_a[16] n59 VDD VSS CKND2
XFE_OFC714_base_plane_8 FE_OCPN1454_base_plane_8 n58 VDD VSS CKND4
XFE_OFC639_base_plane_24 input_a[24] n9 VDD VSS CKND1
XU2 input_b[26] input_c[26] carry[27] VDD VSS AN2D4
XU3 input_c[25] input_b[25] sum[25] VDD VSS CKXOR2D2
XU4 input_a[23] input_b[23] n67 sum[23] VDD VSS XNR3D4
XU5 input_c[23] n67 VDD VSS INVD1
XU6 input_b[22] input_a[22] n31 VDD VSS ND2D1
XU7 n10 n9 n8 VDD VSS ND2D2
XU9 n69 n68 carry[18] VDD VSS ND2D2
XU10 n33 n13 n11 VDD VSS CKND2D3
XU11 input_b[22] n13 VDD VSS INVD2
XU13 input_c[14] n83 VDD VSS INVD4
XU14 input_a[14] input_b[14] n81 VDD VSS NR2D2
XU15 input_c[7] n23 VDD VSS CKND2
XU16 input_b[16] n75 VDD VSS INVD2
XU17 FE_OCPN1210_n3855 FE_OCPN1244_base_plane_10 n47 VDD VSS NR2D3
XU18 input_b[7] input_a[7] n37 VDD VSS CKND2D2
XU19 input_c[6] n86 VDD VSS INVD2
XU20 input_c[2] n46 VDD VSS INVD3
XU22 input_a[5] input_b[5] n79 VDD VSS CKND2D2
XU23 input_a[5] n43 VDD VSS CKND3
XU25 input_c[8] n1 n3 VDD VSS CKND2D2
XU26 n5 n58 n1 VDD VSS CKND2D2
XU27 n3 n2 carry[9] VDD VSS ND2D4
XU28 FE_OCPN1408_base_plane_8 FE_OCPN1241_n2347 n2 VDD VSS ND2D2
XU29 input_a[5] input_b[5] n4 sum[5] VDD VSS XNR3D4
XU30 input_c[5] n4 VDD VSS INVD4
XU31 input_c[8] n25 VDD VSS CKND4
XU32 n42 FE_PSN1657_base_plane_13 n70 VDD VSS CKND2D4
XU33 input_b[8] n5 VDD VSS INVD2
XU34 n7 n6 carry[25] VDD VSS ND2D2
XU35 input_b[24] input_a[24] n6 VDD VSS ND2D1
XU36 input_c[24] n8 n7 VDD VSS CKND2D2
XU37 input_b[24] n10 VDD VSS INVD1
XU39 input_a[16] FE_RN_5 n66 carry[17] VDD VSS IOA21D2
XU41 n11 input_c[22] n32 VDD VSS ND2D4
XU42 n12 input_c[7] n38 VDD VSS CKND2D2
XU43 n30 n29 n12 VDD VSS ND2D2
XU44 input_b[12] FE_OCPN1416_base_plane_12 input_c[12] n19 VDD VSS OAI21D2
XU45 n28 n27 n26 VDD VSS CKND2D2
XU47 input_b[19] input_a[19] n51 VDD VSS NR2D1
XU48 n45 n14 VDD VSS CKND2
XU50 FE_OCPN1425_base_plane_17 FE_RN_2 n68 VDD VSS ND2D2
XU51 n95 n24 carry[3] VDD VSS ND2D4
XU52 input_a[4] n15 VDD VSS CKND4
XU53 FE_OCPN1224_base_plane_3 n14 n96 carry[4] VDD VSS IOA21D4
XU54 n15 input_b[4] input_c[4] sum[4] VDD VSS XNR3D4
XU55 input_a[6] input_b[6] input_c[6] sum[6] VDD VSS XOR3D2
XU56 n49 n48 n47 carry[11] VDD VSS AOI21D4
XU57 input_b[2] n36 VDD VSS INVD2
XU59 input_a[4] n27 VDD VSS CKND2
XU60 input_b[27] input_c[28] carry[28] VDD VSS AN2XD1
XU61 input_c[26] input_b[26] sum[26] VDD VSS XOR2D2
XU62 input_b[25] input_c[25] n78 VDD VSS CKND2D2
XU63 n45 n21 n53 VDD VSS CKND2D2
XU64 input_a[21] FE_OCPN1322_n2362 n87 carry[22] VDD VSS IOA21D2
XU65 input_a[21] n73 VDD VSS INVD1
XU66 n75 n59 n65 VDD VSS CKND2D2
XU68 input_c[18] n22 VDD VSS INVD4
XU69 input_b[1] input_a[1] n93 VDD VSS CKXOR2D4
XU70 input_a[14] input_b[14] n83 sum[14] VDD VSS XNR3D4
XU73 input_c[21] n17 VDD VSS CKND4
XU74 input_c[13] n18 n97 VDD VSS ND2D3
XU75 n41 input_b[13] n18 VDD VSS CKND2D3
XU77 input_a[11] input_c[11] input_b[11] sum[11] VDD VSS XOR3D2
XU78 input_a[13] n42 n20 sum[13] VDD VSS XNR3D4
XU79 input_c[13] n20 VDD VSS INVD4
XU80 n21 input_b[3] input_c[3] sum[3] VDD VSS XNR3D4
XU81 input_a[3] n21 VDD VSS INVD4
XU82 input_a[18] input_b[18] n22 sum[18] VDD VSS XNR3D4
XU83 input_a[7] input_b[7] n23 sum[7] VDD VSS XNR3D4
XU84 input_a[15] input_b[15] n91 sum[15] VDD VSS XNR3D4
XU85 n50 n90 n89 carry[16] VDD VSS AOI21D4
XU86 input_c[15] n91 VDD VSS CKND3
XU87 input_c[2] n34 n95 VDD VSS CKND2D3
XU88 input_b[2] input_a[2] n24 VDD VSS CKND2D2
XU89 input_c[3] n53 n96 VDD VSS ND2D2
XU90 input_b[19] n55 VDD VSS INVD2
XU91 input_a[8] input_b[8] n25 sum[8] VDD VSS XNR3D4
XU92 input_a[20] input_c[20] input_b[20] sum[20] VDD VSS XOR3D2
XU93 input_a[9] input_b[9] n62 VDD VSS NR2D3
XU94 input_a[9] input_b[9] n63 VDD VSS CKND2D4
XU96 input_c[4] n26 n54 VDD VSS ND2D2
XU97 input_b[3] n45 VDD VSS CKND4
XU98 input_a[7] n29 VDD VSS INVD4
XU99 n32 n31 carry[23] VDD VSS ND2D4
XU100 input_a[22] n33 VDD VSS CKND2
XU101 n35 n36 n34 VDD VSS ND2D2
XU102 n38 n37 carry[8] VDD VSS ND2D2
XU103 input_a[15] input_b[15] n89 VDD VSS NR2D3
XU104 input_a[18] input_b[18] n39 VDD VSS NR2D3
XU105 input_a[18] input_b[18] n40 VDD VSS CKND2D3
XU107 n43 n44 n71 VDD VSS ND2D3
XU108 input_a[15] input_b[15] n90 VDD VSS CKND2D3
XU109 input_a[2] input_b[2] n46 sum[2] VDD VSS XNR3D4
XU110 input_b[24] input_a[24] input_c[24] sum[24] VDD VSS XOR3D2
XU111 FE_OCPN1210_n3855 FE_OCPN1244_base_plane_10 n48 VDD VSS CKND2D3
XU112 input_c[10] n49 VDD VSS INVD4
XU113 input_c[15] n50 VDD VSS CKND4
XU115 n52 n51 carry[20] VDD VSS NR2D3
XU116 input_a[19] input_b[19] input_c[19] n52 VDD VSS AOI21D2
XU117 input_b[4] FE_OCPN1200_base_plane_4 n54 carry[5] VDD VSS IOA21D2
XU118 input_a[19] input_c[19] n55 sum[19] VDD VSS XNR3D4
XU119 input_a[22] input_b[22] n56 sum[22] VDD VSS XNR3D4
XU120 input_c[22] n56 VDD VSS CKND4
XU126 input_a[1] n61 VDD VSS INVD1
XU127 input_b[1] input_a[1] n94 carry[2] VDD VSS IOA21D2
XU129 input_c[16] n65 n66 VDD VSS ND2D2
XU131 input_b[1] n60 VDD VSS CKND4
XU132 n64 n63 n62 carry[10] VDD VSS AOI21D4
XU133 input_a[10] input_b[10] n49 sum[10] VDD VSS XNR3D4
XU135 n97 n70 carry[14] VDD VSS ND2D4
XU136 input_c[5] n71 n80 VDD VSS ND2D3
XU137 input_b[6] input_a[6] n84 VDD VSS NR2D2
XU139 input_c[28] input_b[28] sum[28] VDD VSS CKXOR2D1
XU140 n78 carry[26] VDD VSS CKND2
XU141 n80 n79 carry[6] VDD VSS ND2D4
XU142 input_a[14] FE_OCPN1332_n3842 n82 VDD VSS CKND2D3
XU143 input_a[6] input_b[6] n85 VDD VSS ND2D1
XU145 input_a[20] input_b[20] n88 carry[21] VDD VSS IOA21D2
XU147 input_a[0] input_b[0] input_c[0] sum[0] VDD VSS XOR3D1
XU148 input_a[0] input_b[0] input_c[0] n92 VDD VSS OAI21D4
XU149 input_b[0] input_a[0] n92 carry[1] VDD VSS IOA21D2
XU150 input_b[9] input_a[9] input_c[9] sum[9] VDD VSS XOR3D2
XU151 input_a[23] input_b[23] input_c[23] n98 VDD VSS OAI21D1
XU152 input_b[23] input_a[23] n98 carry[24] VDD VSS IOA21D2
XU153 input_a[12] input_b[12] input_c[12] sum[12] VDD VSS XOR3D2
.ENDS

.SUBCKT csa3_WIDTH29_0 input_a[28] input_a[27] input_a[26] input_a[25]
+ input_a[24] input_a[23] input_a[22] input_a[21] input_a[20] input_a[19]
+ input_a[18] input_a[17] input_a[16] input_a[15] input_a[14] input_a[13]
+ input_a[12] input_a[11] input_a[10] input_a[9] input_a[8] input_a[7]
+ input_a[6] input_a[5] input_a[4] input_a[3] input_a[2] input_a[1] input_a[0]
+ input_b[28] input_b[27] input_b[26] input_b[25] input_b[24] input_b[23]
+ input_b[22] input_b[21] input_b[20] input_b[19] input_b[18] input_b[17]
+ input_b[16] input_b[15] input_b[14] input_b[13] input_b[12] input_b[11]
+ input_b[10] input_b[9] input_b[8] input_b[7] input_b[6] input_b[5] input_b[4]
+ input_b[3] input_b[2] input_b[1] input_b[0] input_c[28] input_c[27]
+ input_c[26] input_c[25] input_c[24] input_c[23] input_c[22] input_c[21]
+ input_c[20] input_c[19] input_c[18] input_c[17] input_c[16] input_c[15]
+ input_c[14] input_c[13] input_c[12] input_c[11] input_c[10] input_c[9]
+ input_c[8] input_c[7] input_c[6] input_c[5] input_c[4] input_c[3] input_c[2]
+ input_c[1] input_c[0] sum[28] sum[27] sum[26] sum[25] sum[24] sum[23] sum[22]
+ sum[21] sum[20] sum[19] sum[18] sum[17] sum[16] sum[15] sum[14] sum[13]
+ sum[12] sum[11] sum[10] sum[9] sum[8] sum[7] sum[6] sum[5] sum[4] sum[3]
+ sum[2] sum[1] sum[0] carry[28] carry[27] carry[26] carry[25] carry[24]
+ carry[23] carry[22] carry[21] carry[20] carry[19] carry[18] carry[17]
+ carry[16] carry[15] carry[14] carry[13] carry[12] carry[11] carry[10]
+ carry[9] carry[8] carry[7] carry[6] carry[5] carry[4] carry[3] carry[2]
+ carry[1] carry[0] VDD VSS
XFE_PSC1652_n204 input_c[13] FE_PSN1652_n204 VDD VSS CKBD0
XFE_PSC1648_n3862 input_c[15] FE_PSN1648_n3862 VDD VSS CKBD1
XFE_PSC1640_csa_carry_0_23 input_b[23] FE_PSN1640_csa_carry_0_23 VDD VSS CKBD1
XFE_PSC1627_selected_delta_3_17 input_c[17] FE_PSN1627_selected_delta_3_17 VDD
+ VSS CKBD0
XFE_PSC1621_csa_carry_0_16 input_b[16] FE_PSN1621_csa_carry_0_16 VDD VSS BUFFD2
XFE_PSC1620_csa_carry_0_9 input_b[9] FE_PSN1620_csa_carry_0_9 VDD VSS CKBD1
XFE_OCPC1611_n36 n36 FE_OCPN1611_n36 VDD VSS CKBD1
XFE_OCPC1594_n103 n103 FE_OCPN1594_n103 VDD VSS CKBD1
XFE_OCPC1585_n2359 input_c[19] FE_OCPN1585_n2359 VDD VSS CKBD0
XFE_RC_1754_0 FE_RN_828_0 input_a[14] FE_RN_965_0 VDD VSS IND2D4
XFE_RC_1753_0 input_a[21] FE_RN_787_0 VDD VSS INVD4
XFE_OCPC1579_selected_delta_3_8 input_c[8] FE_OCPN1579_selected_delta_3_8 VDD
+ VSS CKBD0
XFE_OCPC1554_csa_carry_0_3 input_b[3] FE_OCPN1554_csa_carry_0_3 VDD VSS CKBD1
XFE_OCPC1547_csa_carry_0_2 input_b[2] FE_OCPN1547_csa_carry_0_2 VDD VSS CKBD1
XFE_RC_1748_0 FE_RN_790_0 FE_RN_971_0 VDD VSS INVD4
XFE_RC_1747_0 FE_RN_971_0 input_a[21] FE_RN_787_0 FE_RN_790_0 sum[21] VDD VSS
+ OAI22D4
XFE_RC_1740_0 FE_RN_828_0 FE_RN_966_0 VDD VSS INVD2
XFE_RC_1739_0 input_a[14] FE_RN_966_0 FE_RN_965_0 sum[14] VDD VSS OAI21D4
XFE_OCPC1531_n42 n42 FE_OCPN1531_n42 VDD VSS BUFFD2
XFE_OCPC1497_selected_delta_3_16 input_c[16] FE_OCPN1497_selected_delta_3_16
+ VDD VSS BUFFD2
XFE_OCPC1494_csa_carry_0_22 input_b[22] FE_OCPN1494_csa_carry_0_22 VDD VSS
+ CKBD0
XFE_OCPC1468_selected_delta_3_2 input_c[2] FE_OCPN1468_selected_delta_3_2 VDD
+ VSS CKBD1
XFE_OCPC1452_n39 n39 FE_OCPN1452_n39 VDD VSS BUFFD2
XFE_OCPC1439_csa_carry_0_16 FE_PSN1621_csa_carry_0_16
+ FE_OCPN1439_csa_carry_0_16 VDD VSS CKBD1
XFE_OCPC1427_csa_carry_0_21 input_b[21] FE_OCPN1427_csa_carry_0_21 VDD VSS
+ CKBD1
XFE_OCPC1422_csa_carry_0_15 input_b[15] FE_OCPN1422_csa_carry_0_15 VDD VSS
+ BUFFD4
XFE_RC_1612_0 FE_OCPN1222_csa_carry_0_19 n55 VDD VSS BUFFD2
XFE_RC_1582_0 FE_RN_879_0 input_a[23] FE_RN_877_0 VDD VSS IND2D4
XFE_RC_1581_0 n115 input_b[23] FE_RN_878_0 VDD VSS ND2D2
XFE_RC_1580_0 n115 input_b[23] FE_RN_878_0 FE_RN_879_0 VDD VSS OAI21D2
XFE_RC_1579_0 FE_RN_879_0 FE_RN_880_0 VDD VSS INVD1
XFE_RC_1578_0 FE_RN_880_0 input_a[23] FE_RN_877_0 sum[23] VDD VSS OAI21D4
XFE_RC_1538_0 FE_OCPN1594_n103 n104 input_a[15] FE_RN_848_0 VDD VSS IOA21D2
XFE_RC_1537_0 n66 FE_RN_849_0 VDD VSS CKND2
XFE_RC_1536_0 FE_RN_849_0 FE_RN_848_0 carry[16] VDD VSS IND2D4
XFE_RC_1494_0 n36 input_b[14] FE_RN_827_0 VDD VSS ND2D3
XFE_RC_1493_0 n36 input_b[14] FE_RN_827_0 FE_RN_828_0 VDD VSS OAI21D4
XFE_RC_1491_0 input_a[19] FE_RN_824_0 FE_RN_820_0 VDD VSS IND2D4
XFE_RC_1490_0 input_a[19] FE_RN_821_0 VDD VSS INVD2
XFE_RC_1489_0 input_c[19] input_b[19] FE_RN_822_0 VDD VSS IND2D4
XFE_RC_1488_0 input_c[19] FE_RN_823_0 VDD VSS CKND2
XFE_RC_1487_0 input_b[19] FE_RN_823_0 FE_RN_822_0 FE_RN_824_0 VDD VSS OAI21D4
XFE_RC_1486_0 FE_RN_824_0 FE_RN_821_0 FE_RN_820_0 sum[19] VDD VSS OAI21D4
XFE_RC_1480_0 n86 input_b[7] FE_RN_817_0 VDD VSS ND2D2
XFE_RC_1479_0 n86 input_b[7] FE_RN_817_0 FE_RN_393_0 VDD VSS OAI21D2
XFE_RC_1442_0 n86 n87 input_a[7] FE_RN_793_0 VDD VSS IOA21D2
XFE_RC_1441_0 input_c[7] FE_RN_794_0 VDD VSS CKND2
XFE_RC_1440_0 FE_OCPN1206_csa_carry_0_7 FE_RN_794_0 FE_RN_795_0 VDD VSS INR2XD4
XFE_RC_1439_0 FE_RN_795_0 FE_RN_793_0 carry[8] VDD VSS IND2D4
XFE_RC_1438_0 input_b[8] n28 VDD VSS INVD2
XFE_RC_1431_0 input_c[21] input_b[21] FE_RN_788_0 VDD VSS IND2D2
XFE_RC_1430_0 input_b[21] input_c[21] FE_RN_789_0 VDD VSS IND2D4
XFE_RC_1429_0 FE_RN_789_0 FE_RN_788_0 FE_RN_790_0 VDD VSS ND2D4
XFE_RC_1419_0 FE_RN_393_0 FE_RN_780_0 VDD VSS CKND2
XFE_RC_1418_0 FE_RN_780_0 input_a[7] FE_RN_390_0 sum[7] VDD VSS IOA21D4
XFE_RC_1387_0 input_a[10] FE_RN_762_0 FE_RN_760_0 VDD VSS IND2D4
XFE_RC_1386_0 n15 input_b[10] FE_RN_761_0 VDD VSS CKND2D2
XFE_RC_1385_0 n15 input_b[10] FE_RN_761_0 FE_RN_762_0 VDD VSS OAI21D2
XFE_RC_1384_0 FE_RN_762_0 FE_RN_763_0 VDD VSS INVD2
XFE_RC_1383_0 FE_RN_763_0 input_a[10] FE_RN_764_0 VDD VSS ND2D2
XFE_RC_1382_0 FE_RN_764_0 FE_RN_760_0 sum[10] VDD VSS ND2D8
XFE_RC_1368_0 FE_RN_528_0 FE_RN_751_0 VDD VSS INVD4
XFE_RC_1367_0 input_a[3] FE_RN_751_0 FE_RN_752_0 VDD VSS ND2D3
XFE_RC_1366_0 FE_RN_528_0 FE_RN_753_0 VDD VSS INVD2
XFE_RC_1365_0 input_a[3] FE_RN_753_0 FE_RN_752_0 sum[3] VDD VSS OAI21D4
XFE_OCPC1403_n190 input_c[20] FE_OCPN1403_n190 VDD VSS CKBD0
XFE_OCPC1399_n115 n115 FE_OCPN1399_n115 VDD VSS CKBD0
XFE_OCPC1392_n3847 input_c[21] FE_OCPN1392_n3847 VDD VSS CKBD0
XFE_RC_1324_0 input_a[7] FE_RN_731_0 VDD VSS INVD2
XFE_RC_1323_0 FE_RN_731_0 FE_RN_393_0 FE_RN_390_0 VDD VSS CKND2D2
XFE_RC_1322_0 input_c[4] n71 VDD VSS INVD2
XFE_RC_1321_0 input_a[4] FE_RN_725_0 VDD VSS CKND4
XFE_RC_1320_0 FE_RN_730_0 FE_RN_725_0 FE_RN_726_0 VDD VSS ND2D3
XFE_RC_1319_0 input_a[4] FE_RN_727_0 VDD VSS INVD2
XFE_RC_1318_0 input_b[4] input_c[4] FE_RN_728_0 VDD VSS IND2D4
XFE_RC_1317_0 input_b[4] FE_RN_729_0 VDD VSS INVD2
XFE_RC_1316_0 FE_RN_729_0 input_c[4] FE_RN_728_0 FE_RN_730_0 VDD VSS OAI21D4
XFE_RC_1315_0 FE_RN_730_0 FE_RN_727_0 FE_RN_726_0 sum[4] VDD VSS OAI21D4
XFE_RC_1248_0 n103 input_b[15] input_a[15] sum[15] VDD VSS XNR3D4
XFE_RC_1183_0 input_b[24] FE_RN_659_0 VDD VSS INVD1
XFE_RC_1182_0 input_c[24] FE_RN_660_0 VDD VSS INVD1
XFE_RC_1181_0 FE_RN_660_0 FE_RN_659_0 input_a[24] FE_RN_661_0 VDD VSS IOA21D2
XFE_RC_1180_0 input_b[24] FE_RN_662_0 VDD VSS INVD1
XFE_RC_1179_0 input_c[24] FE_RN_662_0 FE_RN_663_0 VDD VSS INR2XD1
XFE_RC_1178_0 FE_RN_663_0 FE_RN_661_0 carry[25] VDD VSS IND2D4
XFE_RC_1177_0 input_b[11] n83 FE_RN_652_0 VDD VSS IND2D2
XFE_OCPC1325_n2356 input_c[5] FE_OCPN1325_n2356 VDD VSS CKBD0
XFE_RC_1170_0 input_c[13] n39 input_a[13] sum[13] VDD VSS XNR3D4
XFE_RC_1164_0 FE_RN_652_0 input_a[11] FE_RN_653_0 VDD VSS ND2D3
XFE_RC_1163_0 input_c[11] FE_RN_654_0 VDD VSS INVD1
XFE_RC_1162_0 input_b[11] FE_RN_654_0 FE_RN_655_0 VDD VSS INR2XD1
XFE_RC_1161_0 FE_RN_655_0 FE_RN_653_0 carry[12] VDD VSS IND2D4
XFE_RC_1091_0 n35 n34 FE_RN_616_0 VDD VSS ND2D2
XFE_RC_1090_0 input_a[5] FE_RN_616_0 n33 VDD VSS ND2D2
XFE_RC_1031_0 n106 n107 FE_RN_578_0 VDD VSS CKND2D2
XFE_RC_1030_0 FE_RN_578_0 n7 n108 VDD VSS ND2D2
XFE_RC_1005_0 input_a[2] FE_OCPN1547_csa_carry_0_2 FE_RN_563_0 VDD VSS ND2D1
XFE_RC_1004_0 n81 FE_RN_563_0 carry[3] VDD VSS CKND2D4
XFE_RC_984_0 input_b[25] input_c[25] FE_RN_553_0 VDD VSS ND2D1
XFE_RC_983_0 n114 FE_RN_553_0 carry[26] VDD VSS ND2D2
XFE_RC_937_0 n11 input_b[3] FE_RN_527_0 VDD VSS ND2D3
XFE_RC_936_0 n11 input_b[3] FE_RN_527_0 FE_RN_528_0 VDD VSS OAI21D4
XFE_RC_861_0 FE_RN_178_0 FE_RN_179_0 input_a[9] FE_RN_476_0 VDD VSS IOA21D2
XFE_RC_860_0 FE_RN_476_0 FE_RN_322_0 carry[10] VDD VSS CKND2D8
XFE_RC_758_0 input_a[12] FE_OCPN1211_csa_carry_0_12 FE_RN_420_0 VDD VSS ND2D1
XFE_RC_757_0 n101 FE_RN_420_0 carry[13] VDD VSS CKND2D4
XFE_RC_737_0 input_a[6] n22 VDD VSS CKND2
XFE_OCPC1272_csa_sum_0_3 input_a[3] FE_OCPN1272_csa_sum_0_3 VDD VSS BUFFD2
XFE_RC_580_0 FE_RN_93_0 FE_RN_322_0 VDD VSS CKND4
XFE_OCPC1262_csa_carry_0_10 input_b[10] FE_OCPN1262_csa_carry_0_10 VDD VSS
+ BUFFD2
XFE_OCPC1257_selected_delta_3_9 input_c[9] FE_OCPN1257_selected_delta_3_9 VDD
+ VSS BUFFD2
XFE_RC_578_0 input_a[6] n53 n3 VDD VSS ND2D2
XFE_RC_436_0 n13 n65 FE_RN_237_0 VDD VSS ND2D2
XFE_RC_435_0 n109 FE_RN_237_0 carry[18] VDD VSS CKND2D4
XFE_RC_429_0 input_b[11] input_c[11] FE_RN_233_0 VDD VSS CKND2D4
XFE_RC_428_0 input_b[11] input_c[11] FE_RN_233_0 n61 VDD VSS OAI21D4
XFE_RC_427_0 n24 n14 FE_RN_232_0 VDD VSS CKND2D2
XFE_RC_426_0 n102 FE_RN_232_0 carry[15] VDD VSS CKND2D4
XFE_RC_341_0 input_c[9] FE_RN_178_0 VDD VSS CKND2
XFE_RC_340_0 input_b[9] FE_RN_179_0 VDD VSS CKND2
XFE_RC_232_0 input_c[17] input_b[17] FE_RN_124_0 VDD VSS ND2D4
XFE_RC_231_0 input_c[17] input_b[17] FE_RN_124_0 n20 VDD VSS OAI21D4
XFE_OCPC1230_csa_sum_0_19 input_a[19] FE_OCPN1230_csa_sum_0_19 VDD VSS BUFFD2
XFE_OCPC1222_csa_carry_0_19 input_b[19] FE_OCPN1222_csa_carry_0_19 VDD VSS
+ CKBD1
XFE_RC_171_0 FE_PSN1620_csa_carry_0_9 FE_OCPN1257_selected_delta_3_9 FE_RN_93_0
+ VDD VSS AN2D4
XFE_OCPC1211_csa_carry_0_12 input_b[12] FE_OCPN1211_csa_carry_0_12 VDD VSS
+ BUFFD2
XFE_OCPC1208_selected_delta_3_16 FE_OCPN1497_selected_delta_3_16
+ FE_OCPN1208_selected_delta_3_16 VDD VSS CKBD4
XFE_OCPC1207_selected_delta_3_6 input_c[6] FE_OCPN1207_selected_delta_3_6 VDD
+ VSS BUFFD4
XFE_OCPC1206_csa_carry_0_7 input_b[7] FE_OCPN1206_csa_carry_0_7 VDD VSS CKBD1
XFE_RC_144_0 input_b[12] n5 input_a[12] sum[12] VDD VSS XNR3D4
XFE_OCPC1176_n2355 input_c[12] FE_OCPN1176_n2355 VDD VSS CKBD0
XFE_OCPC1174_csa_sum_0_10 input_a[10] FE_OCPN1174_csa_sum_0_10 VDD VSS BUFFD2
XFE_RC_127_0 input_b[6] input_c[6] FE_RN_69_0 VDD VSS CKND2D4
XFE_RC_126_0 n10 FE_RN_69_0 n53 VDD VSS ND2D4
XFE_OFC1029_selected_delta_3_6 input_c[6] n56 VDD VSS INVD6
XFE_OFC1026_n3868 n11 n80 VDD VSS CKND1
XFE_OFC1025_n3868 input_c[3] n11 VDD VSS CKND4
XFE_OFC1013_csa_carry_0_15 FE_OCPN1422_csa_carry_0_15 n104 VDD VSS CKND2
XFE_OFC940_csa_carry_0_18 input_b[18] n18 VDD VSS CKND1
XFE_OFC932_selected_delta_3_14 FE_OCPN1611_n36 n14 VDD VSS CKND2
XFE_OFC931_selected_delta_3_14 input_c[14] n36 VDD VSS CKND4
XFE_OFC873_n2299 n71 FE_OFN3402_n2299 VDD VSS CKND1
XFE_OFC830_csa_carry_0_1 input_b[1] n6 VDD VSS CKND2
XFE_OFC724_csa_carry_0_4 input_b[4] n72 VDD VSS CKND1
XFE_OFC581_n3849 n115 FE_OFN2781_n3849 VDD VSS CKND1
XFE_OFC580_n3849 input_c[23] n115 VDD VSS INVD2
XFE_OFC499_csa_carry_0_13 FE_OCPN1452_n39 n52 VDD VSS INVD1
XFE_OFC498_csa_carry_0_13 input_b[13] n39 VDD VSS CKND4
XFE_OFC462_n3848 n49 FE_OFN2772_n3848 VDD VSS CKND1
XFE_OFC461_n3848 input_c[22] n49 VDD VSS CKND3
XU2 input_c[25] input_b[28] input_a[28] sum[28] VDD VSS XOR3D0
XU4 n113 n21 input_a[25] n114 VDD VSS IOA21D1
XU5 n74 n73 carry[23] VDD VSS ND2D3
XU6 input_a[21] FE_OCPN1427_csa_carry_0_21 FE_OCPN1392_n3847 n110 VDD VSS
+ OAI21D2
XU8 n17 n16 carry[19] VDD VSS CKND2D4
XU9 n19 n18 input_a[18] n17 VDD VSS IOA21D2
XU11 input_c[18] n19 VDD VSS INVD2
XU12 input_a[17] n13 VDD VSS BUFFD2
XU14 input_c[20] n79 VDD VSS CKND4
XU17 input_a[16] n32 VDD VSS CKND4
XU21 FE_OCPN1554_csa_carry_0_3 input_a[3] n80 n99 VDD VSS OAI21D2
XU23 input_b[2] n27 VDD VSS CKND2
XU26 n90 FE_OCPN1207_selected_delta_3_6 n31 VDD VSS NR2XD1
XU28 input_c[10] n15 VDD VSS CKND4
XU29 input_b[9] n2 input_a[9] sum[9] VDD VSS XNR3D4
XU30 input_c[9] n2 VDD VSS INVD2
XU31 n4 n3 sum[6] VDD VSS ND2D4
XU33 n22 n76 n4 VDD VSS ND2D2
XU35 n8 n56 n10 VDD VSS CKND2D4
XU36 n53 n76 VDD VSS INVD2
XU37 n57 n68 n59 VDD VSS ND2D4
XU39 input_c[12] n5 VDD VSS INVD2
XU41 n38 n37 carry[14] VDD VSS CKND2D4
XU42 n6 input_c[1] input_a[1] sum[1] VDD VSS XNR3D4
XU43 input_c[5] n34 VDD VSS INVD4
XU44 n32 n7 VDD VSS INVD2
XU45 input_b[6] n8 VDD VSS INVD4
XU47 n40 FE_OCPN1452_n39 input_a[13] n38 VDD VSS IOA21D2
XU50 input_b[14] n24 VDD VSS BUFFD2
XU51 n25 input_a[8] FE_OCPN1579_selected_delta_3_8 n42 VDD VSS OAI21D1
XU52 n25 input_a[8] n41 VDD VSS ND2D1
XU53 input_c[7] n86 VDD VSS INVD3
XU56 input_c[11] n83 VDD VSS INVD2
XU57 input_b[26] n96 VDD VSS INVD0
XU58 input_c[18] input_b[18] n16 VDD VSS ND2D1
XU60 n72 n71 n70 VDD VSS CKND2D2
XU62 FE_PSN1652_n204 n52 n37 VDD VSS ND2D2
XU63 n94 n93 n48 VDD VSS CKND2D2
XU64 input_c[15] n103 VDD VSS INVD4
XU65 input_b[22] n75 VDD VSS INVD1
XU66 n46 n79 n45 VDD VSS CKND2D1
XU67 input_b[25] n113 VDD VSS CKND2
XU68 input_c[28] n21 VDD VSS INVD2
XU70 input_c[6] n90 n89 carry[7] VDD VSS IOA21D2
XU71 n31 n30 VDD VSS INVD1
XU72 input_c[13] n40 VDD VSS INVD1
XU73 input_b[5] n35 VDD VSS INVD1
XU76 n20 n68 VDD VSS INVD4
XU77 input_a[17] n20 n58 VDD VSS ND2D3
XU78 input_b[26] n21 input_a[26] sum[26] VDD VSS XNR3D4
XU80 FE_OCPN1325_n2356 input_b[5] n33 carry[6] VDD VSS IOA21D4
XU81 input_c[10] n23 VDD VSS CKBD1
XU82 input_b[8] n25 VDD VSS CKBD1
XU85 n60 n67 n63 VDD VSS ND2D3
XU86 input_c[2] n27 input_a[2] sum[2] VDD VSS XNR3D4
XU89 input_c[8] n28 input_a[8] sum[8] VDD VSS XNR3D4
XU90 n34 input_b[5] input_a[5] sum[5] VDD VSS XNR3D4
XU92 input_a[17] n57 VDD VSS INVD4
XU95 n59 n58 sum[17] VDD VSS CKND2D4
XU97 n30 input_a[6] n89 VDD VSS CKND2D1
XU98 input_c[16] input_b[16] n32 sum[16] VDD VSS XNR3D4
XU99 n48 FE_OCPN1174_csa_sum_0_10 n95 VDD VSS ND2D3
XU100 n24 n14 input_a[14] n102 VDD VSS OAI21D2
XU103 input_b[18] n19 input_a[18] sum[18] VDD VSS XNR3D4
XU104 FE_OCPN1531_n42 n41 carry[9] VDD VSS CKND2D8
XU105 n63 n62 sum[11] VDD VSS ND2D4
XU106 n44 n43 carry[21] VDD VSS CKND2D2
XU107 input_b[20] FE_OCPN1403_n190 n43 VDD VSS CKND2D1
XU108 input_a[20] n45 n44 VDD VSS ND2D1
XU109 input_b[20] n46 VDD VSS INVD0
XU111 n61 n67 VDD VSS INVD4
XU112 input_a[2] FE_OCPN1547_csa_carry_0_2 FE_OCPN1468_selected_delta_3_2 n81
+ VDD VSS OAI21D2
XU113 n13 n65 FE_PSN1627_selected_delta_3_17 n109 VDD VSS OAI21D4
XU114 input_b[22] n49 input_a[22] sum[22] VDD VSS XNR3D4
XU116 FE_OCPN1208_selected_delta_3_16 FE_OCPN1439_csa_carry_0_16 n108 carry[17]
+ VDD VSS IOA21D4
XU117 input_b[16] n107 VDD VSS INVD0
XU124 input_b[6] n90 VDD VSS BUFFD2
XU125 n55 input_a[19] FE_OCPN1585_n2359 n91 VDD VSS OAI21D1
XU127 FE_OFN3402_n2299 input_b[4] n100 carry[5] VDD VSS IOA21D4
XU128 input_a[11] n61 n62 VDD VSS CKND2D3
XU129 input_a[11] n60 VDD VSS CKND4
XU130 n49 n75 input_a[22] n74 VDD VSS IOA21D2
XU131 input_b[17] n64 VDD VSS INVD0
XU132 n64 n65 VDD VSS INVD1
XU134 FE_OCPN1422_csa_carry_0_15 FE_PSN1648_n3862 n66 VDD VSS ND2D2
XU135 FE_OCPN1262_csa_carry_0_10 n69 VDD VSS BUFFD4
XU137 input_a[4] n70 n100 VDD VSS ND2D2
XU138 input_a[1] input_b[1] n98 carry[2] VDD VSS IOA21D4
XU141 FE_OFN2772_n3848 FE_OCPN1494_csa_carry_0_22 n73 VDD VSS ND2D1
XU142 n77 input_b[24] input_a[24] sum[24] VDD VSS XNR3D4
XU143 input_c[24] n77 VDD VSS INVD4
XU144 input_a[0] input_c[0] carry[1] VDD VSS AN2D2
XU145 input_c[25] n113 input_a[25] sum[25] VDD VSS XNR3D4
XU146 n79 input_b[20] input_a[20] sum[20] VDD VSS XNR3D4
XU147 input_c[28] input_b[27] input_a[27] sum[27] VDD VSS XOR3D2
XU148 input_a[0] input_c[0] sum[0] VDD VSS XOR2D2
XU151 input_b[7] n87 VDD VSS CKND2
XU153 FE_OCPN1230_csa_sum_0_19 n55 n91 carry[20] VDD VSS IOA21D2
XU154 input_a[27] input_b[27] input_c[25] n92 VDD VSS OAI21D1
XU155 input_b[27] input_a[27] n92 carry[28] VDD VSS IOA21D1
XU156 n69 n94 VDD VSS INVD1
XU157 n23 n93 VDD VSS INVD1
XU158 n23 n69 n95 carry[11] VDD VSS IOA21D4
XU159 n21 n96 input_a[26] n97 VDD VSS IOA21D1
XU160 input_b[26] input_c[28] n97 carry[27] VDD VSS IOA21D2
XU161 input_a[1] input_b[1] input_c[1] n98 VDD VSS OAI21D2
XU162 FE_OCPN1554_csa_carry_0_3 FE_OCPN1272_csa_sum_0_3 n99 carry[4] VDD VSS
+ IOA21D4
XU163 input_a[12] FE_OCPN1211_csa_carry_0_12 FE_OCPN1176_n2355 n101 VDD VSS
+ OAI21D1
XU165 FE_OCPN1208_selected_delta_3_16 n106 VDD VSS CKND2
XU167 input_a[21] FE_OCPN1427_csa_carry_0_21 n110 carry[22] VDD VSS IOA21D4
XU168 FE_PSN1640_csa_carry_0_23 n111 VDD VSS INVD1
XU169 FE_OCPN1399_n115 n111 input_a[23] n112 VDD VSS IOA21D1
XU170 FE_PSN1640_csa_carry_0_23 FE_OFN2781_n3849 n112 carry[24] VDD VSS IOA21D2
.ENDS

.SUBCKT recip_lut level[1] level[0] y_fraction_msb[2] y_fraction_msb[1]
+ y_fraction_msb[0] reciprocal_square[7] reciprocal_square[6]
+ reciprocal_square[5] reciprocal_square[4] reciprocal_square[3]
+ reciprocal_square[2] reciprocal_square[1] reciprocal_square[0] VDD VSS
XFE_OFC1094_n15 n36 FE_OFN3424_n15 VDD VSS CKND2
XFE_OFC1093_n15 n15 n36 VDD VSS BUFFD4
XFE_OFC1049_y_20 n18 FE_OFN2742_y_20 VDD VSS CKND1
XFE_OFC1048_y_20 n18 n3 VDD VSS CKND1
XFE_OFC1043_y_20 y_fraction_msb[0] n18 VDD VSS CKND1
XFE_OFC915_y_21 y_fraction_msb[1] n15 VDD VSS CKND1
XFE_OFC256_level_1 n39 n29 VDD VSS CKND1
XFE_OFC255_level_1 n39 n20 VDD VSS CKND1
XFE_OFC251_level_1 level[1] n24 VDD VSS CKND1
XFE_OFC250_level_1 level[1] n39 VDD VSS CKND1
XFE_OFC91_n34 n34 FE_OFN91_n34 VDD VSS CKBD1
XU3 n19 n29 n34 VDD VSS IND2D1
XU5 y_fraction_msb[2] n41 VDD VSS INVD1
XU7 n16 n29 n5 n35 n17 VDD VSS AOI22D0
XU8 FE_OFN3424_n15 n5 n42 VDD VSS NR2XD0
XU9 n10 n36 n14 VDD VSS CKND2D1
XU12 n19 n24 n26 n13 reciprocal_square[4] VDD VSS AO211D1
XU13 n19 n22 n17 reciprocal_square[5] VDD VSS AO21D1
XU14 n1 n3 n10 VDD VSS CKND2D1
XU15 n8 n14 n9 VDD VSS CKND2D1
XU16 n27 n26 n7 VDD VSS OR2D0
XU17 n31 n42 n32 VDD VSS NR2D1
XU18 n25 FE_OFN91_n34 n13 VDD VSS NR2XD0
XU19 n38 n37 n40 VDD VSS NR2D1
XU20 n14 n39 n22 VDD VSS NR2D1
XU21 n35 n29 n33 VDD VSS CKND2D1
XU22 n20 n19 n21 VDD VSS NR2D1
XU23 n30 n1 VDD VSS INVD1
XU24 reciprocal_square[7] n23 reciprocal_square[6] VDD VSS ND2D2
XU25 n29 n38 n9 n25 reciprocal_square[2] VDD VSS OAI211D1
XU26 n42 n41 n40 n39 reciprocal_square[0] VDD VSS AOI211D1
XU27 n31 n34 n4 n21 reciprocal_square[7] VDD VSS MOAI22D1
XU28 n22 n23 VDD VSS INVD1
XU29 n4 FE_OFN3424_n15 n25 VDD VSS ND2D1
XU30 n41 n19 VDD VSS CKND2
XU32 level[0] n30 VDD VSS INVD1
XU34 n30 n4 VDD VSS INVD1
XU35 n30 n5 VDD VSS INVD1
XU37 n28 n7 reciprocal_square[1] VDD VSS NR2D2
XU38 n25 n18 n31 VDD VSS NR2D1
XU39 n1 n38 VDD VSS INVD1
XU40 FE_OFN91_n34 n8 VDD VSS INVD0
XU42 n10 n11 VDD VSS INVD0
XU43 n11 n36 n12 VDD VSS CKND2D0
XU45 n5 n12 n20 n26 VDD VSS MUX2ND0
XU46 n36 FE_OFN2742_y_20 n1 n16 VDD VSS OAI21D0
XU47 n41 n35 VDD VSS INVD1
XU48 n25 n41 n24 FE_OFN2742_y_20 n28 VDD VSS NR4D0
XU49 FE_OFN91_n34 FE_OFN3424_n15 n4 n35 n27 VDD VSS OAI22D0
XU50 FE_OFN91_n34 n33 n32 reciprocal_square[3] VDD VSS MUX2ND0
XU51 FE_OFN3424_n15 n35 FE_OFN2742_y_20 n37 VDD VSS AOI21D0
.ENDS

.SUBCKT sa_scale_VALUE_WIDTH29_COEFF_WIDTH8 value[28] value[27] value[26]
+ value[25] value[24] value[23] value[22] value[21] value[20] value[19]
+ value[18] value[17] value[16] value[15] value[14] value[13] value[12]
+ value[11] value[10] value[9] value[8] value[7] value[6] value[5] value[4]
+ value[3] value[2] value[1] value[0] coefficient[7] coefficient[6]
+ coefficient[5] coefficient[4] coefficient[3] coefficient[2] coefficient[1]
+ coefficient[0] scaled_value[28] scaled_value[27] scaled_value[26]
+ scaled_value[25] scaled_value[24] scaled_value[23] scaled_value[22]
+ scaled_value[21] scaled_value[20] scaled_value[19] scaled_value[18]
+ scaled_value[17] scaled_value[16] scaled_value[15] scaled_value[14]
+ scaled_value[13] scaled_value[12] scaled_value[11] scaled_value[10]
+ scaled_value[9] scaled_value[8] scaled_value[7] scaled_value[6]
+ scaled_value[5] scaled_value[4] scaled_value[3] scaled_value[2]
+ scaled_value[1] scaled_value[0] VDD VSS FE_OCPN3_shared_plane_12
+ FE_OCPN4_shared_plane_25 FE_OCPN5_shared_plane_24 FE_OCPN7_n178 FE_OCPN6_n178
XFE_PSC1655_n218 n218 FE_PSN1655_n218 VDD VSS CKBD4
XFE_PSC1646_n534 n534 FE_PSN1646_n534 VDD VSS CKBD2
XFE_PSC1639_n738 n738 FE_PSN1639_n738 VDD VSS BUFFD2
XFE_PSC1630_n453 n453 FE_PSN1630_n453 VDD VSS CKBD1
XFE_PSC1625_n1169 n1169 FE_PSN1625_n1169 VDD VSS CKBD0
XFE_PSC1623_n944 n944 FE_PSN1623_n944 VDD VSS CKBD4
XFE_PSC1622_n906 n906 FE_PSN1622_n906 VDD VSS CKBD1
XFE_PSC1618_n450 n450 FE_PSN1618_n450 VDD VSS CKBD1
XFE_OCPC1610_n367 n367 FE_OCPN1610_n367 VDD VSS BUFFD2
XFE_OCPC1606_n112 n112 FE_OCPN1606_n112 VDD VSS CKBD1
XFE_OCPC1602_n859 n859 FE_OCPN1602_n859 VDD VSS CKBD0
XFE_OCPC1599_FE_OFN86_shared_plane_13 FE_OFN86_shared_plane_13
+ FE_OCPN1599_FE_OFN86_shared_plane_13 VDD VSS CKBD0
XFE_OCPC1596_n1191 n1191 FE_OCPN1596_n1191 VDD VSS CKBD1
XFE_OCPC1593_n730 n730 FE_OCPN1593_n730 VDD VSS CKBD4
XFE_OCPC1581_n917 n917 FE_OCPN1581_n917 VDD VSS BUFFD4
XFE_OCPC1577_n112 n112 FE_OCPN1577_n112 VDD VSS BUFFD4
XFE_OCPC1576_n394 n394 FE_OCPN1576_n394 VDD VSS CKBD1
XFE_OCPC1575_n1209 n1209 FE_OCPN1575_n1209 VDD VSS CKBD0
XFE_OCPC1572_n287 n287 FE_OCPN1572_n287 VDD VSS CKBD1
XFE_OCPC1564_n4 n4 FE_OCPN1564_n4 VDD VSS CKBD0
XFE_OCPC1563_n790 n790 FE_OCPN1563_n790 VDD VSS CKBD1
XFE_OCPC1561_n745 n745 FE_OCPN1561_n745 VDD VSS CKBD1
XFE_OCPC1558_n1210 n1210 FE_OCPN1558_n1210 VDD VSS CKBD1
XFE_OCPC1539_n1198 n1198 FE_OCPN1539_n1198 VDD VSS CKBD0
XFE_OCPC1538_n980 n980 FE_OCPN1538_n980 VDD VSS CKBD1
XFE_OCPC1535_n367 n367 FE_OCPN1535_n367 VDD VSS BUFFD2
XFE_OCPC1534_n821 n821 FE_OCPN1534_n821 VDD VSS BUFFD2
XFE_OCPC1533_n773 n773 FE_OCPN1533_n773 VDD VSS CKBD1
XFE_OCPC1532_n896 n896 FE_OCPN1532_n896 VDD VSS BUFFD2
XFE_OCPC1530_n1232 n1232 FE_OCPN1530_n1232 VDD VSS CKBD0
XFE_OCPC1524_FE_RN_22 FE_RN_22 FE_OCPN1524_FE_RN_22 VDD VSS CKBD0
XFE_OCPC1523_FE_RN_514_0 FE_RN_514_0 FE_OCPN1523_FE_RN_514_0 VDD VSS CKBD4
XFE_OCPC1522_n1098 n1098 FE_OCPN1522_n1098 VDD VSS BUFFD2
XFE_OCPC1521_shared_plane_27 value[27] FE_OCPN1521_shared_plane_27 VDD VSS
+ BUFFD2
XFE_OCPC1519_n1154 n1154 FE_OCPN1519_n1154 VDD VSS CKBD1
XFE_OCPC1517_n28 n28 FE_OCPN1517_n28 VDD VSS BUFFD2
XFE_OCPC1512_n858 n858 FE_OCPN1512_n858 VDD VSS CKBD1
XFE_OCPC1511_n1052 n1052 FE_OCPN1511_n1052 VDD VSS CKBD1
XFE_OCPC1506_n86 n86 FE_OCPN1506_n86 VDD VSS CKBD1
XFE_OCPC1502_n352 n352 FE_OCPN1502_n352 VDD VSS CKBD0
XFE_OCPC1501_n1173 n1173 FE_OCPN1501_n1173 VDD VSS CKBD0
XFE_OCPC1500_n1201 n1201 FE_OCPN1500_n1201 VDD VSS CKBD1
XFE_OCPC1482_n1209 FE_OCPN1575_n1209 FE_OCPN1482_n1209 VDD VSS CKBD1
XFE_OCPC1471_n1029 n1029 FE_OCPN1471_n1029 VDD VSS BUFFD2
XFE_OCPC1458_n191 FE_OCPN1389_n191 FE_OCPN1458_n191 VDD VSS CKBD1
XFE_OCPC1451_n1035 n1035 FE_OCPN1451_n1035 VDD VSS BUFFD4
XFE_OCPC1450_n992 n992 FE_OCPN1450_n992 VDD VSS BUFFD4
XFE_OCPC1443_n1070 n1070 FE_OCPN1443_n1070 VDD VSS BUFFD1
XFE_OCPC1436_n919 n919 FE_OCPN1436_n919 VDD VSS BUFFD2
XFE_OCPC1435_n285 n285 FE_OCPN1435_n285 VDD VSS CKBD1
XFE_OCPC1426_n1132 n1132 FE_OCPN1426_n1132 VDD VSS CKBD1
XFE_OCPC1417_n206 n206 FE_OCPN1417_n206 VDD VSS BUFFD1
XFE_OCPC1224_shared_plane_21_dup value[21] FE_RN_42 VDD VSS BUFFD8
XFE_RC_458_0_dup FE_OFN1347_n944 n945 n943 FE_RN_33 VDD VSS IOA21D2
XFE_RC_1688_0 FE_OFN3498_n920 FE_RN_17 FE_RN_928_0 VDD VSS ND2D3
XFE_RC_1687_0 FE_OFN3498_n920 FE_RN_17 FE_OFN1346_n919 FE_RN_929_0 VDD VSS
+ OAI21D4
XFE_RC_1686_0 FE_RN_929_0 FE_RN_928_0 n990 VDD VSS CKND2D4
XFE_RC_1671_0 n434 FE_RN_919_0 VDD VSS INVD1
XFE_RC_1670_0 FE_RN_919_0 n876 n432 VDD VSS ND2D2
XFE_RC_1669_0 n165 FE_OFN2761_reciprocal_square_0 FE_OFN1344_n425 VDD VSS ND2D8
XFE_RC_1668_0 FE_RN_280_0 FE_RN_282_0 FE_RN_918_0 VDD VSS CKND2D2
XFE_RC_1667_0 FE_RN_918_0 n172 n20 VDD VSS IND2D4
XFE_RC_1655_0 FE_RN_832_0 FE_RN_910_0 VDD VSS INVD1
XFE_RC_1654_0 FE_RN_834_0 FE_RN_910_0 FE_RN_911_0 VDD VSS IND2D2
XFE_RC_1653_0 FE_RN_911_0 FE_RN_830_0 FE_RN_912_0 VDD VSS ND2D4
XFE_RC_1652_0 FE_RN_912_0 n994 n1150 VDD VSS ND2D8
XFE_RC_1632_0 n452 FE_RN_897_0 VDD VSS INVD1
XFE_RC_1631_0 FE_RN_897_0 n451 FE_RN_898_0 VDD VSS IND2D1
XFE_RC_1630_0 FE_RN_898_0 FE_PSN1618_n450 n903 VDD VSS ND2D2
XFE_RC_1629_0 n452 FE_RN_899_0 VDD VSS INVD1
XFE_RC_1628_0 FE_RN_899_0 n451 FE_RN_900_0 VDD VSS IND2D1
XFE_RC_1627_0 FE_RN_900_0 n450 FE_OFN1380_n903 VDD VSS ND2D2
XFE_RC_1604_0 FE_OFN1344_n425 FE_RN_884_0 VDD VSS INVD1
XFE_RC_1603_0 n424 FE_RN_885_0 VDD VSS INVD1
XFE_RC_1602_0 FE_RN_885_0 n196 FE_RN_884_0 FE_RN_886_0 VDD VSS IND3D2
XFE_RC_1601_0 FE_RN_109_0 FE_RN_886_0 FE_RN_106_0 FE_RN_108_0 n330 VDD VSS
+ IND4D4
XFE_RC_1591_0 FE_OFN80_shared_plane_26 FE_OFN3490_n398 FE_RN_19 VDD VSS CKND2D4
XFE_RC_1589_0 n917 FE_OFN1381_n917 VDD VSS BUFFD8
XFE_RC_1588_0 FE_OCPN1581_n917 n941 VDD VSS INVD6
XFE_RC_1568_0 n730 FE_RN_860_0 VDD VSS INVD2
XFE_RC_1567_0 FE_RN_866_0 FE_RN_861_0 VDD VSS INVD1
XFE_RC_1566_0 FE_RN_870_0 FE_RN_861_0 FE_RN_862_0 VDD VSS NR2D2
XFE_RC_1565_0 FE_RN_870_0 FE_RN_863_0 VDD VSS INVD1
XFE_RC_1564_0 n731 FE_RN_864_0 VDD VSS INVD1
XFE_RC_1563_0 FE_RN_869_0 FE_RN_864_0 FE_RN_863_0 FE_RN_865_0 VDD VSS IOA21D2
XFE_RC_1562_0 FE_RN_865_0 FE_OCPN1593_n730 FE_RN_862_0 FE_RN_860_0 n725 VDD VSS
+ OAI22D4
XFE_RC_1561_0 n731 FE_RN_869_0 FE_RN_866_0 VDD VSS IND2D4
XFE_RC_1560_0 FE_RN_866_0 n730 FE_RN_867_0 VDD VSS ND2D3
XFE_RC_1559_0 FE_OFN2774_reciprocal_square_4 FE_RN_868_0 VDD VSS INVD1
XFE_RC_1558_0 n297 FE_RN_868_0 FE_RN_869_0 VDD VSS IND2D4
XFE_RC_1557_0 n731 FE_RN_869_0 FE_RN_870_0 VDD VSS INR2D4
XFE_RC_1556_0 FE_RN_870_0 FE_RN_867_0 n736 VDD VSS IND2D4
XFE_RC_1555_0 FE_RN_512_0 FE_RN_859_0 VDD VSS INVD2
XFE_RC_1554_0 FE_RN_859_0 n1035 FE_RN_509_0 FE_RN_514_0 VDD VSS OAI21D4
XFE_RC_1547_0 n690 n689 n523 FE_RN_854_0 VDD VSS OAI21D2
XFE_RC_1546_0 FE_RN_854_0 n463 n709 VDD VSS ND2D2
XFE_RC_1545_0 n136 n135 VDD VSS INVD2
XFE_RC_1544_0 FE_RN_853_0 n508 FE_RN_851_0 VDD VSS CKND2D4
XFE_RC_1543_0 n134 n136 FE_RN_852_0 VDD VSS ND2D4
XFE_RC_1542_0 n134 n136 FE_RN_852_0 FE_RN_853_0 VDD VSS OAI21D4
XFE_RC_1541_0 FE_RN_853_0 n508 FE_RN_851_0 n901 VDD VSS OAI21D4
XFE_RC_1534_0 n1122 FE_RN_846_0 VDD VSS INVD1
XFE_RC_1533_0 FE_RN_846_0 FE_RN_757_0 FE_RN_847_0 VDD VSS IND2D4
XFE_RC_1532_0 FE_RN_847_0 FE_RN_756_0 scaled_value[27] VDD VSS CKND2D4
XFE_RC_1504_0 FE_RN_831_0 FE_RN_829_0 VDD VSS INVD1
XFE_RC_1503_0 FE_RN_834_0 FE_RN_829_0 FE_RN_830_0 VDD VSS ND2D2
XFE_RC_1502_0 n977 FE_OCPN1435_n285 n977 FE_OCPN1435_n285 FE_RN_831_0 VDD VSS
+ MOAI22D1
XFE_RC_1501_0 FE_RN_831_0 FE_RN_832_0 VDD VSS INVD2
XFE_RC_1500_0 n411 n973 n411 n973 FE_RN_833_0 VDD VSS MOAI22D1
XFE_RC_1499_0 FE_RN_833_0 n976 FE_RN_833_0 n976 FE_RN_834_0 VDD VSS MOAI22D1
XFE_RC_1482_0 n64 FE_OFN3413_shared_plane_7 VDD VSS CKND16
XFE_RC_1481_0 n805 n64 n520 VDD VSS INR2XD4
XFE_RC_1473_0 value[8] n460 n459 VDD VSS ND2D8
XFE_RC_1456_0 n843 FE_RN_796_0 VDD VSS INVD1
XFE_RC_1455_0 FE_RN_806_0 n844 FE_RN_797_0 VDD VSS ND2D2
XFE_RC_1454_0 FE_RN_806_0 n844 FE_RN_797_0 FE_RN_798_0 VDD VSS OAI21D2
XFE_RC_1453_0 FE_RN_798_0 FE_RN_796_0 FE_RN_799_0 VDD VSS ND2D2
XFE_RC_1452_0 n844 FE_RN_806_0 FE_RN_800_0 VDD VSS INR2D4
XFE_RC_1451_0 FE_RN_800_0 FE_RN_803_0 FE_RN_801_0 VDD VSS IND2D4
XFE_RC_1450_0 FE_RN_801_0 n843 FE_RN_802_0 VDD VSS CKND2D4
XFE_RC_1449_0 FE_RN_802_0 FE_RN_799_0 n862 VDD VSS CKND2D4
XFE_RC_1448_0 n844 FE_RN_806_0 FE_RN_803_0 VDD VSS IND2D4
XFE_RC_1447_0 FE_RN_803_0 n843 FE_RN_804_0 VDD VSS ND2D3
XFE_RC_1446_0 FE_OFN2747_reciprocal_square_3 FE_RN_805_0 VDD VSS INVD1
XFE_RC_1445_0 FE_RN_805_0 FE_OFN85_shared_plane_16 FE_RN_806_0 VDD VSS IND2D4
XFE_RC_1444_0 n844 FE_RN_806_0 FE_RN_807_0 VDD VSS INR2XD4
XFE_RC_1443_0 FE_RN_807_0 FE_RN_804_0 n877 VDD VSS IND2D4
XFE_OCPC1406_n1197 n1197 FE_OCPN1406_n1197 VDD VSS CKBD0
XFE_OCPC1405_n822 n822 FE_OCPN1405_n822 VDD VSS CKBD4
XFE_RC_1401_0 n128 n129 FE_RN_305_0 VDD VSS ND2D4
XFE_RC_1399_0 n1091 FE_RN_771_0 VDD VSS CKND2
XFE_RC_1398_0 n149 n148 FE_RN_771_0 FE_RN_772_0 VDD VSS ND3D4
XFE_RC_1397_0 n149 n148 FE_RN_773_0 VDD VSS CKND2D4
XFE_RC_1396_0 FE_RN_773_0 n1091 FE_RN_774_0 VDD VSS CKND2D4
XFE_RC_1395_0 FE_RN_774_0 FE_RN_772_0 scaled_value[25] VDD VSS CKND2D4
XFE_RC_1394_0 n766 n263 n112 FE_RN_765_0 VDD VSS NR3D3
XFE_RC_1393_0 n263 FE_RN_766_0 VDD VSS CKND2
XFE_RC_1392_0 FE_RN_766_0 n766 FE_OCPN1606_n112 FE_RN_765_0 FE_RN_767_0 VDD VSS
+ AOI31D4
XFE_RC_1391_0 n112 n766 FE_RN_768_0 VDD VSS INR2D2
XFE_RC_1390_0 n112 FE_RN_769_0 VDD VSS INVD3
XFE_RC_1389_0 FE_RN_769_0 n766 n263 FE_RN_768_0 n263 FE_RN_770_0 VDD VSS
+ AOI32D2
XFE_RC_1388_0 FE_RN_770_0 FE_RN_767_0 n779 VDD VSS CKND2D4
XFE_RC_698_0_dup n1016 n1015 FE_RN_32 VDD VSS CKND2D4
XU328_dup n1102 n376 FE_RN_31 VDD VSS ND2D4
XU198_dup n126 n237 FE_RN_22 VDD VSS CKND2D4
XFE_RC_1375_0 n1122 FE_RN_755_0 VDD VSS CKND1
XFE_RC_1374_0 FE_RN_384_0 FE_RN_21_0 FE_RN_755_0 FE_RN_756_0 VDD VSS ND3D3
XFE_RC_1373_0 FE_RN_384_0 FE_RN_21_0 FE_RN_757_0 VDD VSS CKND2D4
XFE_OCPC1287_FE_RN_1 FE_RN_1 n1140 VDD VSS CKND1
XFE_OFC1384_n918_dup n918 FE_RN_17 VDD VSS BUFFD4
XFE_OCPC1404_n1186 n1186 FE_OCPN1404_n1186 VDD VSS CKBD0
XFE_RC_1363_0 n206 n1138 n1139 FE_RN_748_0 VDD VSS OAI21D4
XFE_RC_1362_0 FE_RN_5 n1134 FE_RN_748_0 FE_RN_749_0 VDD VSS AOI21D4
XFE_RC_1361_0 n340 n1131 FE_RN_750_0 VDD VSS CKND2D3
XFE_RC_1360_0 FE_RN_16 FE_RN_750_0 FE_RN_749_0 n191 VDD VSS OAI21D4
XFE_RC_1359_0 FE_RN_53_0 n1195 FE_RN_52_0 n1184 VDD VSS OAI21D4
XU301_dup n1158 n1159 FE_RN_41 VDD VSS NR2XD2
XFE_RC_136_0_dup n1097 n1094 n1098 FE_RN_40 VDD VSS OAI21D4
XU124_dup n165 FE_OFN2761_reciprocal_square_0 FE_RN_39 VDD VSS ND2D4
XU261_dup n1 FE_OFN2758_n6 FE_RN_38 VDD VSS CKND2D4
XFE_OFC1353_shared_plane_22_dup FE_OFN83_shared_plane_22 FE_RN_37 VDD VSS
+ BUFFD4
XU292_dup FE_RN_26 n20 FE_RN_36 VDD VSS ND2D4
XFE_RC_1356_0 FE_RN_1 n1132 FE_RN_5 VDD VSS NR2D8
XU140_dup FE_RN_9 FE_OFN2747_reciprocal_square_3 FE_RN_35 VDD VSS CKND2D4
XFE_OFC570_shared_plane_26_dup n56 FE_RN_34 VDD VSS INVD6
XFE_OCPC1396_FE_OFN83_shared_plane_22 FE_OFN83_shared_plane_22
+ FE_OCPN1396_FE_OFN83_shared_plane_22 VDD VSS BUFFD4
XFE_OCPC1389_n191 n191 FE_OCPN1389_n191 VDD VSS BUFFD2
XU807_dup n998 n999 FE_RN_1 VDD VSS NR2XD4
XFE_OFC1278_n920 FE_OFN3497_n920 FE_OFN3499_n920 VDD VSS CKND4
XFE_OFC1277_n920 FE_OFN3497_n920 FE_OFN3498_n920 VDD VSS CKND6
XFE_OFC1276_n920 n920 FE_OFN3497_n920 VDD VSS INVD4
XFE_OFC1384_n918 n918 FE_OFN1384_n918 VDD VSS BUFFD4
XFE_OFC1274_n942 FE_OFN3493_n942 FE_OFN3495_n942 VDD VSS CKND6
XFE_OFC1273_n942 FE_OFN3493_n942 FE_OFN3494_n942 VDD VSS INVD6
XFE_OFC1272_n942 n942 FE_OFN3493_n942 VDD VSS INVD6
XFE_OFC1271_n599 n599 FE_OFN3492_n599 VDD VSS CKBD0
XFE_OFC1379_n480 n480 FE_OFN1379_n480 VDD VSS BUFFD4
XFE_OFC1270_n420 n420 FE_OFN3491_n420 VDD VSS CKBD0
XFE_OFC1269_n398 n398 FE_OFN3490_n398 VDD VSS BUFFD1
XFE_OFC1378_n272 n272 FE_OFN1378_n272 VDD VSS BUFFD8
XFE_OFC1268_n269 n269 FE_OFN3489_n269 VDD VSS CKBD0
XFE_OFC1353_shared_plane_22 FE_OFN83_shared_plane_22 FE_OFN1353_shared_plane_22
+ VDD VSS BUFFD8
XFE_OFC1258_FE_OFN2762_reciprocal_square_0 FE_OFN2762_reciprocal_square_0
+ FE_OFN3479_FE_OFN2762_reciprocal_square_0 VDD VSS CKBD0
XFE_OFC1256_n1025 n1025 FE_OFN3477_n1025 VDD VSS BUFFD1
XFE_OFC1347_n944 n944 FE_OFN1347_n944 VDD VSS BUFFD4
XFE_OFC1346_n919 n919 FE_OFN1346_n919 VDD VSS BUFFD8
XFE_OFC1345_n534 n534 FE_OFN1345_n534 VDD VSS BUFFD4
XFE_RC_1346_0 FE_OFN1345_n534 FE_OFN1379_n480 FE_OFN1378_n272 FE_RN_738_0 VDD
+ VSS IND3D4
XFE_RC_1345_0 FE_OFN1345_n534 FE_OFN1378_n272 FE_RN_739_0 VDD VSS INR2D4
XFE_RC_1344_0 FE_RN_739_0 FE_RN_35 FE_RN_740_0 VDD VSS ND2D2
XFE_RC_1343_0 FE_RN_35 FE_RN_741_0 VDD VSS CKND2
XFE_RC_1342_0 FE_RN_35 FE_RN_742_0 VDD VSS CKND2
XFE_RC_1341_0 n534 FE_RN_743_0 VDD VSS CKND2
XFE_RC_1340_0 n272 FE_RN_744_0 VDD VSS CKND2
XFE_RC_1339_0 FE_RN_744_0 FE_RN_743_0 FE_RN_742_0 FE_OFN1378_n272 FE_RN_741_0
+ FE_OFN1345_n534 FE_RN_745_0 VDD VSS AOI33XD4
XFE_RC_1338_0 FE_RN_745_0 FE_RN_740_0 FE_RN_738_0 n775 VDD VSS ND3D2
XFE_RC_1337_0 n789 FE_RN_736_0 VDD VSS INVD1
XFE_RC_1336_0 FE_OCPN1563_n790 FE_RN_736_0 n115 VDD VSS IND2D4
XFE_RC_1335_0 n789 n790 FE_RN_737_0 VDD VSS NR2D3
XFE_RC_1334_0 FE_RN_737_0 n1198 FE_RN_53_0 VDD VSS IND2D4
XFE_OCPC1241_n178 FE_OCPN6_n178 FE_OCPN1238_n178 VDD VSS INVD4
XFE_OCPC1240_n178 FE_OCPN6_n178 FE_RN_30 VDD VSS CKND8
XFE_OCPC1239_n178 FE_OCPN6_n178 n75 VDD VSS INVD16
XFE_OCPC1237_n178 value[23] n327 VDD VSS INVD6
XFE_RC_1299_0 value[14] n69 VDD VSS INVD6
XFE_RC_1298_0 value[14] n70 VDD VSS BUFFD4
XFE_RC_1297_0 n322 value[14] n112 VDD VSS AN2D8
XFE_OCPC1235_n79 n79 FE_OCPN3473_n79 VDD VSS BUFFD4
XFE_OCPC1234_shared_plane_24 n168 FE_RN_8 VDD VSS CKND4
XFE_OCPC1232_shared_plane_24 value[24] n168 VDD VSS CKND4
XFE_OCPC1231_shared_plane_24 value[24] n54 VDD VSS BUFFD16
XFE_OCPC1230_shared_plane_25 FE_OFN2806_shared_plane_25
+ FE_OCPN3471_shared_plane_25 VDD VSS CKND2
XFE_OCPC1229_shared_plane_25 n436 FE_OFN81_shared_plane_25 VDD VSS INVD6
XFE_OCPC1228_shared_plane_25 n436 FE_OFN2806_shared_plane_25 VDD VSS BUFFD4
XFE_OCPC1227_shared_plane_25 n436 n76 VDD VSS CKND12
XFE_OCPC1225_shared_plane_25 value[25] n436 VDD VSS INVD6
XFE_RC_736_0_dup n1073 FE_RN_32 n1071 FE_RN_29 VDD VSS OAI21D4
XFE_OCPC1224_shared_plane_21 value[21] n1 VDD VSS BUFFD4
XFE_OCPC1223_shared_plane_21 value[21] FE_RN_4 VDD VSS BUFFD8
XFE_RC_1254_0 n110 n395 FE_OCPN1326_n220 FE_RN_13 n960 VDD VSS OAI22D4
XFE_RC_1247_0 n1219 n352 n698 n1217 VDD VSS AOI21D4
XU823_dup n1092 n1097 FE_RN_28 VDD VSS NR2D3
XU820_dup FE_RN_29 FE_RN_28 FE_RN_40 FE_RN_27 VDD VSS AOI21D4
XU293_dup n949 n947 n217 FE_RN_26 VDD VSS XNR3D4
XFE_OCPC1326_n220 n220 FE_OCPN1326_n220 VDD VSS CKBD4
XU282_dup n54 n1025 FE_RN_25 VDD VSS ND2D4
XFE_RC_1237_0 FE_RN_547_0 n403 n400 n787 VDD VSS OAI21D4
XFE_RC_1198_0 n246 n245 n920 VDD VSS ND2D2
XFE_RC_1197_0 n246 FE_RN_671_0 VDD VSS INVD1
XFE_RC_1196_0 n245 FE_RN_671_0 FE_RN_145_0 VDD VSS INR2XD1
XU382_dup FE_RN_37 FE_OFN3477_n1025 FE_RN_24 VDD VSS ND2D4
XU794_dup FE_OFN3489_n269 n327 FE_RN_23 VDD VSS INR2XD2
XFE_RC_1135_0 FE_OCPN1610_n367 FE_RN_637_0 VDD VSS INVD2
XFE_RC_1134_0 n83 FE_RN_637_0 FE_RN_638_0 VDD VSS IND2D4
XFE_RC_1133_0 n106 n366 FE_RN_638_0 n1031 VDD VSS OAI21D4
XFE_RC_1132_0 n218 FE_PSN1630_n453 FE_RN_636_0 VDD VSS CKND2D2
XFE_RC_1131_0 FE_RN_636_0 n899 n450 VDD VSS CKND2D2
XFE_RC_1129_0 n1100 FE_RN_634_0 VDD VSS INVD1
XFE_RC_1128_0 FE_RN_634_0 n151 FE_RN_635_0 VDD VSS IND2D4
XFE_RC_1127_0 FE_RN_635_0 n166 scaled_value[24] VDD VSS CKND2D4
XFE_RC_1115_0 FE_OCPN1316_n148 n1228 n1226 n1229 VDD VSS OAI21D2
XFE_RC_1109_0 n1145 n1146 FE_RN_625_0 VDD VSS IND2D1
XFE_RC_1108_0 n1145 n1146 FE_RN_626_0 VDD VSS INR2D1
XFE_RC_1107_0 FE_RN_626_0 FE_RN_625_0 scaled_value[19] VDD VSS IND2D4
XFE_RC_1086_0 n445 n275 FE_RN_611_0 VDD VSS CKND2D3
XFE_RC_1085_0 FE_RN_611_0 n735 FE_RN_612_0 VDD VSS ND2D3
XFE_RC_1084_0 n443 FE_RN_613_0 VDD VSS INVD1
XFE_RC_1083_0 FE_RN_613_0 FE_RN_612_0 n362 VDD VSS IND2D4
XFE_RC_1068_0 n901 FE_RN_598_0 VDD VSS INVD1
XFE_RC_1067_0 n902 FE_RN_599_0 VDD VSS INVD1
XFE_RC_1066_0 FE_RN_184_0 FE_RN_599_0 FE_RN_600_0 VDD VSS IND2D2
XFE_RC_1065_0 FE_RN_600_0 FE_RN_183_0 FE_RN_601_0 VDD VSS ND2D2
XFE_RC_1064_0 FE_RN_601_0 FE_RN_598_0 FE_RN_186_0 VDD VSS ND2D2
XFE_RC_1058_0 n739 FE_PSN1639_n738 n737 n384 VDD VSS OAI21D4
XFE_RC_1057_0 n212 FE_RN_589_0 VDD VSS INVD1
XFE_RC_1056_0 FE_RN_594_0 FE_RN_589_0 FE_RN_590_0 VDD VSS CKND2D4
XFE_RC_1055_0 n212 FE_RN_591_0 VDD VSS INVD1
XFE_RC_1054_0 n453 n218 FE_RN_592_0 VDD VSS IND2D4
XFE_RC_1053_0 n453 FE_RN_593_0 VDD VSS INVD1
XFE_RC_1052_0 FE_RN_593_0 FE_PSN1655_n218 FE_RN_592_0 FE_RN_594_0 VDD VSS
+ OAI21D4
XFE_RC_1051_0 FE_RN_594_0 FE_RN_591_0 FE_RN_590_0 n210 VDD VSS OAI21D4
XFE_RC_1042_0 n495 n5 FE_RN_583_0 VDD VSS CKND2D3
XFE_RC_1041_0 n565 FE_RN_583_0 n145 VDD VSS CKND2D4
XFE_RC_1040_0 n387 FE_RN_19 FE_RN_582_0 VDD VSS ND2D3
XFE_RC_1039_0 FE_RN_582_0 n248 FE_RN_511_0 VDD VSS CKND2D3
XFE_RC_1033_0 n162 n959 FE_RN_579_0 VDD VSS ND2D1
XFE_RC_1032_0 n160 FE_RN_579_0 n1007 VDD VSS ND2D2
XFE_OCPC1316_n148 n148 FE_OCPN1316_n148 VDD VSS CKBD1
XFE_RC_1020_0 n277 FE_RN_570_0 VDD VSS CKND2
XFE_RC_1019_0 n279 FE_RN_570_0 FE_RN_571_0 VDD VSS ND2D2
XFE_RC_1018_0 n277 FE_RN_572_0 VDD VSS CKND2
XFE_RC_1017_0 n279 FE_RN_572_0 FE_RN_571_0 n276 VDD VSS OAI21D2
XFE_RC_1010_0 FE_RN_349_0 FE_RN_345_0 FE_RN_347_0 FE_RN_343_0 n970 VDD VSS
+ IND4D4
XFE_RC_981_0 n918 FE_RN_151_0 FE_OCPN1436_n919 FE_RN_154_0 VDD VSS IND3D4
XFE_RC_980_0 n303 n128 FE_RN_552_0 VDD VSS ND2D3
XFE_RC_979_0 FE_RN_552_0 n129 n304 VDD VSS IND2D4
XFE_RC_978_0 n1157 n1137 n1136 n1142 VDD VSS AOI21D2
XFE_RC_977_0 FE_RN_203_0 n513 FE_RN_199_0 n777 VDD VSS OAI21D2
XFE_RC_969_0 n740 FE_RN_547_0 VDD VSS INVD2
XFE_RC_958_0 value[13] n311 VDD VSS BUFFD8
XFE_RC_957_0 n319 value[13] n527 VDD VSS INR2XD2
XFE_RC_920_0 FE_RN_512_0 n374 VDD VSS CKND3
XFE_RC_919_0 n1034 FE_RN_505_0 VDD VSS INVD2
XFE_RC_918_0 FE_RN_514_0 FE_RN_505_0 FE_RN_506_0 VDD VSS ND2D2
XFE_RC_917_0 n1034 FE_RN_507_0 VDD VSS CKND2
XFE_RC_916_0 FE_RN_512_0 FE_RN_508_0 VDD VSS CKND4
XFE_RC_915_0 FE_RN_508_0 n1035 FE_RN_509_0 VDD VSS ND2D4
XFE_RC_914_0 n247 FE_RN_510_0 VDD VSS CKND2
XFE_RC_912_0 FE_RN_511_0 FE_RN_510_0 FE_RN_512_0 VDD VSS ND2D4
XFE_RC_909_0 FE_OCPN1523_FE_RN_514_0 FE_RN_507_0 FE_RN_506_0 n1038 VDD VSS
+ OAI21D4
XFE_RC_867_0 n689 FE_RN_478_0 VDD VSS CKND1
XFE_RC_866_0 n276 FE_RN_478_0 FE_RN_479_0 VDD VSS ND2D2
XFE_RC_865_0 n689 FE_RN_480_0 VDD VSS CKND1
XFE_RC_864_0 n276 FE_RN_480_0 FE_RN_479_0 n692 VDD VSS OAI21D2
XFE_OCPC1309_n1071 n1071 FE_OCPN1309_n1071 VDD VSS CKBD1
XFE_OCPC1308_n1016 n1016 FE_OCPN1308_n1016 VDD VSS CKBD1
XU800_dup1 n1138 n206 n1139 FE_RN_21 VDD VSS OAI21D4
XFE_RC_760_0 FE_RN_3 n181 FE_RN_421_0 VDD VSS CKND2D2
XFE_RC_759_0 n180 FE_RN_421_0 n1027 VDD VSS CKND2D3
XFE_RC_736_0 n1073 FE_RN_389_0 n1071 n1101 VDD VSS OAI21D4
XFE_RC_719_0 value[21] FE_OFN2761_reciprocal_square_0 n105 VDD VSS AN2D4
XU904_dup n1149 n1154 n1150 FE_RN_20 VDD VSS OAI21D4
XFE_RC_698_0 n1016 n1015 FE_RN_389_0 VDD VSS CKND2D4
XFE_OCPC1198_shared_plane_12 FE_RN_9 n35 VDD VSS CKND3
XFE_OCPC1197_shared_plane_12 value[12] n295 VDD VSS BUFFD8
XFE_OCPC1196_shared_plane_12 value[12] FE_RN_9 VDD VSS INVD8
XFE_RC_688_0 n191 n1117 FE_RN_384_0 VDD VSS ND2D4
XFE_OCPC1303_n905 n905 FE_OCPN1303_n905 VDD VSS CKBD4
XFE_RC_681_0 n511 n385 n43 VDD VSS IND2D4
XFE_RC_680_0 n1106 FE_RN_379_0 VDD VSS INVD1
XFE_RC_679_0 FE_RN_379_0 FE_RN_305_0 FE_RN_380_0 VDD VSS IND2D4
XFE_RC_678_0 FE_RN_380_0 n304 scaled_value[23] VDD VSS ND2D4
XFE_OCPC1182_shared_plane_28 n163 FE_OCPN3450_shared_plane_28 VDD VSS INVD4
XFE_OCPC1181_shared_plane_28 n163 FE_OCPN1248_shared_plane_28 VDD VSS INVD4
XFE_OCPC1180_shared_plane_28 value[28] n163 VDD VSS CKND3
XFE_OCPC1179_shared_plane_28 value[28] FE_RN_7 VDD VSS BUFFD8
XFE_OCPC1178_shared_plane_28 value[28] FE_OFN79_shared_plane_28 VDD VSS BUFFD4
XFE_RC_661_0 n90 n88 n93 n1136 VDD VSS OAI21D2
XU290_dup1 FE_RN_20 FE_RN_5 FE_RN_21 FE_RN_18 VDD VSS AOI21D4
XU291_dup n1018 FE_RN_41 n331 FE_RN_16 VDD VSS AOI21D4
XFE_RC_651_0 FE_RN_364_0 FE_RN_357_0 VDD VSS INVD1
XFE_RC_650_0 FE_RN_366_0 FE_RN_357_0 n847 FE_RN_358_0 VDD VSS OAI21D2
XFE_RC_649_0 FE_RN_366_0 FE_RN_359_0 VDD VSS INVD1
XFE_RC_648_0 n849 FE_RN_360_0 VDD VSS INVD1
XFE_RC_647_0 n848 FE_RN_361_0 VDD VSS INVD1
XFE_RC_646_0 FE_RN_361_0 FE_RN_360_0 FE_RN_359_0 FE_RN_362_0 VDD VSS IOA21D2
XFE_RC_645_0 FE_RN_362_0 n847 FE_RN_358_0 n868 VDD VSS OAI21D2
XFE_RC_644_0 n848 FE_RN_363_0 VDD VSS INVD2
XFE_RC_643_0 n849 FE_RN_363_0 FE_RN_364_0 VDD VSS IND2D4
XFE_RC_642_0 FE_RN_364_0 n847 FE_RN_365_0 VDD VSS ND2D3
XFE_RC_641_0 n848 n849 FE_RN_366_0 VDD VSS AN2D8
XFE_RC_640_0 FE_RN_366_0 FE_RN_365_0 n860 VDD VSS IND2D4
XU759_dup n1130 n1001 FE_RN_14 FE_RN_15 VDD VSS OAI21D4
XFE_RC_624_0 FE_OFN1381_n917 FE_OFN3494_n942 FE_OFN1347_n944 FE_RN_343_0 VDD
+ VSS ND3D3
XFE_RC_623_0 FE_PSN1623_n944 FE_RN_344_0 VDD VSS CKND2
XFE_RC_622_0 n917 FE_OFN3495_n942 FE_RN_344_0 FE_RN_345_0 VDD VSS IND3D4
XFE_RC_621_0 FE_PSN1623_n944 FE_RN_346_0 VDD VSS CKND2
XFE_RC_620_0 FE_OFN3494_n942 FE_OFN1381_n917 FE_RN_346_0 FE_RN_347_0 VDD VSS
+ IND3D4
XFE_RC_619_0 FE_PSN1623_n944 FE_RN_348_0 VDD VSS CKND2
XFE_RC_618_0 FE_OFN1381_n917 FE_OFN3495_n942 FE_RN_348_0 FE_RN_349_0 VDD VSS
+ NR3D3
XU290_dup FE_RN_20 FE_RN_5 n377 FE_RN_14 VDD VSS AOI21D4
XFE_RC_615_0 FE_RN_339_0 FE_RN_330_0 VDD VSS INVD1
XFE_RC_614_0 FE_RN_338_0 n723 FE_RN_330_0 n772 VDD VSS AO21D4
XFE_RC_613_0 FE_RN_338_0 FE_RN_339_0 FE_RN_331_0 VDD VSS CKND2D4
XFE_RC_612_0 FE_RN_331_0 n723 FE_RN_332_0 VDD VSS ND2D3
XFE_RC_611_0 n724 FE_RN_333_0 VDD VSS INVD1
XFE_RC_610_0 n521 FE_RN_334_0 VDD VSS INVD2
XFE_RC_609_0 n724 FE_RN_334_0 FE_RN_333_0 n521 FE_RN_335_0 VDD VSS AOI22D2
XFE_RC_608_0 FE_RN_335_0 n723 FE_RN_332_0 n728 VDD VSS OAI21D4
XFE_RC_607_0 n116 FE_RN_336_0 VDD VSS INVD1
XFE_RC_606_0 n724 FE_RN_337_0 VDD VSS INVD2
XFE_RC_605_0 n521 FE_RN_337_0 FE_RN_338_0 VDD VSS IND2D4
XFE_RC_604_0 n724 n521 FE_RN_339_0 VDD VSS CKND2D3
XFE_RC_603_0 FE_RN_339_0 FE_RN_340_0 VDD VSS INVD1
XFE_RC_602_0 FE_RN_340_0 n723 FE_RN_338_0 FE_RN_341_0 VDD VSS OAI21D2
XFE_RC_601_0 FE_RN_341_0 FE_RN_336_0 FE_RN_342_0 VDD VSS CKND2D2
XFE_RC_600_0 FE_RN_342_0 n771 n405 VDD VSS ND2D2
XFE_OCPC1293_n468 n468 FE_OCPN1293_n468 VDD VSS CKBD1
XFE_OCPC1288_n468 n468 FE_OCPN1288_n468 VDD VSS CKBD1
XFE_OCPC1284_n242 n242 FE_OCPN1284_n242 VDD VSS BUFFD1
XFE_OCPC1282_n1150 n1150 FE_OCPN1282_n1150 VDD VSS CKBD0
XFE_OCPC1280_n774 n774 FE_OCPN1280_n774 VDD VSS BUFFD2
XFE_OCPC1278_n418 n418 FE_OCPN1278_n418 VDD VSS BUFFD2
XFE_OCPC1277_n982 n982 FE_OCPN1277_n982 VDD VSS BUFFD2
XFE_OCPC1274_n1185 n1185 FE_OCPN1274_n1185 VDD VSS BUFFD0
XU96_dup FE_RN_30 FE_OFN3492_n599 FE_RN_13 VDD VSS CKND2D4
XFE_OCPC1273_shared_plane_17 value[17] FE_OCPN1273_shared_plane_17 VDD VSS
+ BUFFD4
XU200_dup n486 n485 FE_RN_12 VDD VSS ND2D4
XU208_dup n76 FE_OFN3491_n420 FE_RN_11 VDD VSS ND2D4
XFE_OCPC1171_n1132 FE_OCPN1426_n1132 n87 VDD VSS CKND1
XU254_dup FE_OFN79_shared_plane_28 FE_OFN3479_FE_OFN2762_reciprocal_square_0
+ FE_RN_10 VDD VSS CKND2D4
XFE_OCPC1261_n551 FE_RN_12 FE_OCPN1261_n551 VDD VSS CKBD0
XFE_OCPC1259_n785 n785 FE_OCPN1259_n785 VDD VSS CKBD1
XFE_OCPC1258_n480 FE_OFN1379_n480 FE_OCPN1258_n480 VDD VSS BUFFD4
XFE_OCPC1255_n974 n974 FE_OCPN1255_n974 VDD VSS BUFFD4
XFE_RC_270_0_dup n169 FE_RN_144_0 FE_RN_6 VDD VSS CKND2D4
XFE_OCPC1253_n1204 n1204 FE_OCPN1253_n1204 VDD VSS BUFFD1
XFE_OCPC1252_n244 n244 FE_OCPN1252_n244 VDD VSS CKBD0
XFE_OCPC1170_n64 FE_OFN3413_shared_plane_7 n65 VDD VSS CKND6
XFE_OCPC1168_n64 n64 n392 VDD VSS CKND12
XFE_OCPC1249_n1185 FE_OCPN1274_n1185 FE_OCPN1249_n1185 VDD VSS CKBD0
XFE_OCPC1167_shared_plane_19 n63 FE_OCPN1236_shared_plane_19 VDD VSS CKND12
XFE_OCPC1166_shared_plane_19 n63 n62 VDD VSS CKND8
XFE_OCPC1165_shared_plane_19 n63 n61 VDD VSS CKND6
XFE_OCPC1164_shared_plane_19 value[19] n63 VDD VSS INVD8
XFE_OCPC1149_shared_plane_18 n51 n52 VDD VSS CKND6
XFE_OCPC1148_shared_plane_18 value[18] n51 VDD VSS INVD4
XFE_OCPC1147_shared_plane_18 value[18] n204 VDD VSS INVD3
XFE_OCPC1146_shared_plane_18 value[18] n122 VDD VSS BUFFD8
XFE_RC_539_0 n386 FE_RN_283_0 VDD VSS INVD6
XFE_RC_538_0 FE_RN_290_0 FE_RN_283_0 FE_RN_284_0 VDD VSS ND2D4
XFE_RC_537_0 n386 FE_RN_285_0 VDD VSS INVD3
XFE_RC_536_0 FE_RN_290_0 FE_RN_285_0 FE_RN_284_0 n138 VDD VSS OAI21D4
XFE_RC_535_0 FE_RN_291_0 FE_RN_286_0 VDD VSS CKND2
XFE_RC_534_0 FE_RN_295_0 FE_RN_286_0 FE_RN_287_0 VDD VSS ND2D2
XFE_RC_533_0 FE_RN_290_0 n386 FE_RN_288_0 VDD VSS ND2D3
XFE_RC_532_0 n952 n495 FE_RN_289_0 VDD VSS ND2D4
XFE_RC_531_0 n952 n495 FE_RN_289_0 FE_RN_290_0 VDD VSS OAI21D4
XFE_RC_530_0 FE_RN_290_0 n386 FE_RN_288_0 FE_RN_291_0 VDD VSS OAI21D2
XFE_RC_529_0 FE_RN_291_0 FE_RN_292_0 VDD VSS INVD1
XFE_RC_528_0 n960 n961 FE_RN_293_0 VDD VSS IND2D4
XFE_RC_527_0 n960 FE_RN_294_0 VDD VSS INVD1
XFE_RC_526_0 FE_RN_294_0 n961 FE_RN_293_0 FE_RN_295_0 VDD VSS OAI21D4
XFE_RC_525_0 FE_RN_295_0 FE_RN_292_0 FE_RN_287_0 n964 VDD VSS OAI21D2
XFE_RC_521_0 FE_RN_279_0 n941 n943 VDD VSS CKND2D3
XFE_RC_520_0 n916 FE_RN_278_0 VDD VSS INVD1
XFE_RC_519_0 FE_RN_278_0 FE_OFN3495_n942 FE_RN_279_0 VDD VSS IND2D4
XFE_RC_518_0 FE_RN_279_0 n941 FE_RN_280_0 VDD VSS ND2D2
XFE_RC_517_0 FE_OFN1347_n944 FE_RN_281_0 VDD VSS INVD1
XFE_RC_516_0 FE_RN_281_0 n945 FE_RN_282_0 VDD VSS IND2D2
XFE_RC_508_0 n373 FE_OCPN1451_n1035 FE_RN_275_0 VDD VSS ND2D3
XFE_RC_507_0 n371 FE_RN_275_0 n1053 VDD VSS CKND2D2
XFE_OCPC1140_n902 n902 FE_OCPN3446_n902 VDD VSS BUFFD4
XFE_RC_504_0 n1234 n1231 n1232 n1219 VDD VSS OAI21D4
XFE_RC_503_0 n214 FE_RN_272_0 VDD VSS INVD2
XFE_RC_502_0 n225 FE_RN_272_0 FE_RN_273_0 VDD VSS IND2D4
XFE_RC_501_0 n222 n224 FE_RN_273_0 n966 VDD VSS OAI21D4
XFE_RC_458_0 FE_OFN1347_n944 n945 n943 n979 VDD VSS IOA21D2
XFE_RC_455_0 n1124 n1126 n1127 n1225 VDD VSS OAI21D4
XFE_RC_445_0 n249 n1239 n1240 n1237 VDD VSS OAI21D4
XFE_RC_420_0 n490 n491 n489 n488 n987 VDD VSS OAI22D2
XFE_RC_400_0 n390 FE_RN_217_0 VDD VSS CKND2
XFE_RC_398_0 n45 FE_RN_217_0 FE_RN_219_0 VDD VSS ND2D3
XFE_RC_397_0 n138 n391 FE_RN_219_0 n1004 VDD VSS OAI21D4
XFE_RC_392_0 n458 FE_RN_213_0 VDD VSS INVD2
XFE_RC_391_0 n457 FE_RN_213_0 FE_RN_214_0 VDD VSS IND2D4
XFE_RC_390_0 n454 n456 FE_RN_214_0 n969 VDD VSS OAI21D4
XFE_RC_389_0 FE_OFN3499_n920 n918 FE_RN_147_0 FE_RN_148_0 VDD VSS IND3D4
XFE_RC_381_0 n872 n873 FE_RN_209_0 VDD VSS ND2D2
XFE_RC_380_0 n482 FE_RN_209_0 n913 VDD VSS CKND2D4
XFE_RC_377_0 FE_RN_205_0 FE_RN_198_0 VDD VSS INVD2
XFE_RC_376_0 FE_RN_208_0 FE_RN_198_0 n513 FE_RN_199_0 VDD VSS OAI21D2
XFE_RC_375_0 FE_RN_208_0 FE_RN_200_0 VDD VSS INVD1
XFE_RC_374_0 n770 FE_RN_201_0 VDD VSS INVD1
XFE_RC_373_0 n769 FE_RN_202_0 VDD VSS INVD1
XFE_RC_372_0 FE_RN_202_0 FE_RN_201_0 FE_RN_200_0 FE_RN_203_0 VDD VSS IOA21D2
XFE_RC_370_0 n769 FE_RN_204_0 VDD VSS INVD2
XFE_RC_369_0 n770 FE_RN_204_0 FE_RN_205_0 VDD VSS IND2D2
XFE_RC_368_0 FE_RN_205_0 n513 FE_RN_206_0 VDD VSS ND2D2
XFE_RC_367_0 n770 FE_RN_207_0 VDD VSS INVD3
XFE_RC_366_0 n769 FE_RN_207_0 FE_RN_208_0 VDD VSS INR2XD4
XFE_RC_365_0 FE_RN_208_0 FE_RN_206_0 n801 VDD VSS IND2D4
XFE_RC_357_0 n903 FE_RN_182_0 VDD VSS INVD1
XFE_RC_356_0 FE_RN_182_0 FE_OCPN3446_n902 FE_RN_183_0 VDD VSS ND2D2
XFE_RC_355_0 n903 FE_RN_184_0 VDD VSS INVD1
XFE_RC_352_0 FE_OFN1380_n903 n902 FE_RN_191_0 FE_RN_187_0 VDD VSS IOA21D2
XFE_RC_351_0 FE_RN_187_0 n901 FE_RN_188_0 VDD VSS ND2D2
XFE_RC_350_0 FE_RN_188_0 FE_RN_186_0 n911 VDD VSS CKND2D3
XFE_RC_349_0 FE_OFN1380_n903 FE_OCPN3446_n902 FE_RN_189_0 VDD VSS CKND2D4
XFE_RC_348_0 FE_OFN1380_n903 FE_RN_190_0 VDD VSS INVD4
XFE_RC_347_0 n902 FE_RN_190_0 FE_RN_191_0 VDD VSS IND2D4
XFE_RC_346_0 FE_RN_191_0 n901 FE_RN_192_0 VDD VSS ND2D4
XFE_RC_345_0 FE_RN_192_0 FE_RN_189_0 n918 VDD VSS CKND2D8
XFE_OCPC1235_n1184 n1184 FE_OCPN1235_n1184 VDD VSS CKBD1
XFE_RC_315_0 n427 FE_RN_170_0 VDD VSS INVD2
XFE_RC_314_0 n428 FE_RN_170_0 FE_RN_171_0 VDD VSS IND2D2
XFE_RC_313_0 n426 n280 FE_RN_171_0 n953 VDD VSS OAI21D4
XFE_RC_300_0 n785 n783 n784 n790 VDD VSS XOR3D4
XFE_RC_299_0 FE_OCPN1278_n418 n966 FE_RN_165_0 VDD VSS ND2D2
XFE_RC_298_0 n415 FE_RN_165_0 n954 VDD VSS ND2D4
XFE_RC_292_0 n145 n6 n1011 VDD VSS CKND2D2
XFE_RC_291_0 FE_RN_161_0 n1010 FE_RN_158_0 VDD VSS ND2D2
XFE_RC_290_0 n216 FE_RN_160_0 FE_RN_159_0 VDD VSS ND2D2
XFE_RC_289_0 n6 n145 FE_RN_160_0 VDD VSS ND2D3
XFE_RC_288_0 FE_RN_160_0 n216 FE_RN_159_0 FE_RN_161_0 VDD VSS OAI21D2
XFE_RC_287_0 FE_RN_161_0 n1010 FE_RN_158_0 n1014 VDD VSS OAI21D2
XFE_RC_281_0 FE_RN_145_0 n919 n918 FE_RN_146_0 VDD VSS IND3D2
XFE_RC_280_0 FE_OFN1346_n919 FE_RN_147_0 VDD VSS INVD4
XFE_RC_278_0 FE_OFN1384_n918 FE_OFN1346_n919 FE_RN_149_0 VDD VSS NR2D4
XFE_RC_277_0 FE_RN_149_0 FE_OFN3498_n920 FE_RN_150_0 VDD VSS CKND2D4
XFE_RC_276_0 FE_OFN3499_n920 FE_RN_151_0 VDD VSS CKND2
XFE_RC_272_0 FE_RN_154_0 FE_RN_150_0 FE_RN_148_0 FE_RN_146_0 n927 VDD VSS ND4D3
XFE_RC_271_0 n171 FE_RN_33 FE_RN_144_0 VDD VSS CKND2D4
XFE_RC_270_0 FE_RN_36 FE_RN_144_0 n973 VDD VSS CKND2D4
XFE_RC_256_0 n293 n292 n291 n963 VDD VSS OAI21D4
XFE_RC_247_0 n483 n484 FE_RN_132_0 VDD VSS ND2D2
XFE_RC_246_0 FE_RN_132_0 n871 n482 VDD VSS ND2D3
XFE_RC_197_0 FE_RN_38 FE_OFN1344_n425 n196 FE_RN_106_0 VDD VSS IND3D4
XFE_RC_196_0 FE_RN_38 n196 FE_RN_107_0 VDD VSS INR2D4
XFE_RC_195_0 FE_RN_107_0 FE_OFN1344_n425 FE_RN_108_0 VDD VSS ND2D4
XFE_RC_194_0 n196 FE_OFN1344_n425 n424 FE_RN_109_0 VDD VSS NR3D1
XFE_RC_178_0 n793 n1201 FE_RN_95_0 VDD VSS NR2D4
XFE_RC_177_0 n1197 FE_RN_95_0 FE_RN_52_0 VDD VSS INR2D4
XFE_OCPC1213_n1205 n1205 FE_OCPN1213_n1205 VDD VSS CKBD0
XFE_OCPC1186_n1134 n1134 FE_OCPN1186_n1134 VDD VSS BUFFD2
XFE_OCPC1184_FE_OFN80_shared_plane_26 FE_OFN80_shared_plane_26
+ FE_OCPN1184_FE_OFN80_shared_plane_26 VDD VSS BUFFD4
XFE_OCPC1183_n1164 n1164 FE_OCPN1183_n1164 VDD VSS CKBD0
XFE_OCPC1182_n209 n209 FE_OCPN1182_n209 VDD VSS CKBD0
XFE_OCPC1171_n206 FE_OCPN1417_n206 FE_OCPN1171_n206 VDD VSS CKBD1
XFE_OCPC1170_n56 n56 FE_OCPN1170_n56 VDD VSS CKBD0
XFE_OCPC1168_n356 n356 FE_OCPN1168_n356 VDD VSS CKBD0
XFE_OCPC1163_n341 n341 FE_OCPN1163_n341 VDD VSS CKBD0
XFE_OCPC1162_n1180 n1180 FE_OCPN1162_n1180 VDD VSS CKBD1
XFE_OCPC1158_n221 n221 FE_OCPN1158_n221 VDD VSS CKBD0
XFE_RC_136_0 n1097 n1094 n1098 n182 VDD VSS OAI21D4
XFE_OCPC1151_n1175 n1175 FE_OCPN1151_n1175 VDD VSS CKBD0
XFE_RC_104_0 FE_RN_27 n1125 n1124 n229 VDD VSS OAI21D4
XFE_RC_102_0 n448 n449 FE_RN_54_0 VDD VSS CKND2D2
XFE_RC_101_0 FE_RN_54_0 n860 n447 VDD VSS ND2D3
XFE_RC_96_0 n926 FE_RN_50_0 VDD VSS CKND2
XFE_RC_95_0 n925 FE_RN_50_0 FE_RN_51_0 VDD VSS IND2D4
XFE_RC_94_0 n924 FE_RN_51_0 n283 VDD VSS ND2D2
XFE_RC_93_0 FE_OCPN1389_n191 n1017 FE_RN_49_0 VDD VSS ND2D3
XFE_RC_92_0 FE_OCPN1389_n191 n1017 FE_RN_49_0 scaled_value[21] VDD VSS OAI21D4
XU262_dup n231 FE_OCPN1535_n367 n366 FE_RN_3 VDD VSS XNR3D4
XFE_OCPC1145_n1170 n1170 FE_OCPN1145_n1170 VDD VSS CKBD0
XFE_RC_91_0 n150 n228 FE_RN_48_0 VDD VSS ND2D2
XFE_RC_90_0 FE_RN_48_0 n227 n226 scaled_value[26] VDD VSS ND3D4
XFE_OCPC1142_n1168 n1168 FE_OCPN1142_n1168 VDD VSS CKBD0
XFE_OCPC1139_n1139 n1139 FE_OCPN1139_n1139 VDD VSS CKBD0
XU259_dup n29 FE_RN_11 n948 FE_RN_2 VDD VSS XNR3D4
XFE_RC_52_0 n511 FE_RN_30_0 VDD VSS CKND2
XFE_RC_51_0 n385 FE_RN_30_0 n43 scaled_value[22] VDD VSS OAI21D4
XFE_RC_39_0 n153 FE_RN_21_0 VDD VSS INVD4
XFE_OFC1088_shared_plane_3 n36 n37 VDD VSS CKND2
XFE_OFC1087_shared_plane_3 value[3] n36 VDD VSS CKND4
XFE_OFC1086_shared_plane_3 value[3] n314 VDD VSS CKND2
XFE_OFC1083_reciprocal_square_2 n1003 n399 VDD VSS CKND2
XFE_OFC1082_reciprocal_square_2 n937 n585 VDD VSS BUFFD3
XFE_OFC1081_reciprocal_square_2 n937 n1003 VDD VSS CKND1
XFE_OFC1080_reciprocal_square_2 n757 n937 VDD VSS CKND2
XFE_OFC1079_reciprocal_square_2 coefficient[2] n757 VDD VSS CKND2
XFE_OFC1066_shared_plane_9 n38 n313 VDD VSS CKND1
XFE_OFC1065_shared_plane_9 value[9] n38 VDD VSS CKND6
XFE_OFC1064_shared_plane_9 value[9] n370 VDD VSS INVD2
XFE_OFC1057_n159 n159 n155 VDD VSS CKND1
XFE_OFC1033_n320 n320 n128 VDD VSS CKND6
XFE_OFC1010_reciprocal_square_6 n796 FE_OFN3414_reciprocal_square_6 VDD VSS
+ INVD3
XFE_OFC1009_reciprocal_square_6 n446 n584 VDD VSS CKND1
XFE_OFC1008_reciprocal_square_6 n446 n796 VDD VSS CKND2
XFE_OFC1007_reciprocal_square_6 n446 n721 VDD VSS CKND1
XFE_OFC1006_reciprocal_square_6 n840 n446 VDD VSS CKND2
XFE_OFC1005_reciprocal_square_6 coefficient[6] n840 VDD VSS CKND2
XFE_OFC1004_n699 n699 n137 VDD VSS CKND2
XFE_OFC992_shared_plane_7 value[7] n64 VDD VSS INVD12
XFE_OFC989_n1190 n1190 n1192 VDD VSS CKND1
XFE_OFC988_shared_plane_5 value[5] n324 VDD VSS INVD4
XFE_OFC987_shared_plane_5 value[5] n94 VDD VSS INVD3
XFE_OFC976_shared_plane_16 FE_OFN2766_shared_plane_16 n336 VDD VSS INVD4
XFE_OFC975_shared_plane_16 FE_OFN84_shared_plane_16 FE_OFN2766_shared_plane_16
+ VDD VSS CKND6
XFE_OFC974_shared_plane_16 FE_OFN84_shared_plane_16 FE_OFN85_shared_plane_16
+ VDD VSS INVD6
XFE_OFC973_shared_plane_16 FE_OFN84_shared_plane_16 FE_OFN2767_shared_plane_16
+ VDD VSS CKND2
XFE_OFC959_n473 n473 n472 VDD VSS INVD4
XFE_OFC954_n857 n857 n281 VDD VSS CKND2
XFE_OFC953_n1149 n1149 n1151 VDD VSS CKND1
XFE_OFC949_n1214 n1214 n1216 VDD VSS CKND1
XFE_OFC945_n164 n164 n1009 VDD VSS CKND4
XFE_OFC942_n886 n886 n485 VDD VSS CKND6
XFE_OFC920_shared_plane_2 n605 n323 VDD VSS CKND1
XFE_OFC919_shared_plane_2 value[2] n605 VDD VSS CKND2
XFE_OFC918_shared_plane_2 value[2] FE_OFN90_shared_plane_2 VDD VSS CKND2
XFE_OFC890_n716 n701 n768 VDD VSS CKND2
XFE_OFC889_n716 n957 n701 VDD VSS CKND2
XFE_OFC888_n716 n716 n957 VDD VSS CKND2
XFE_OFC847_n459 n459 n763 VDD VSS INVD6
XFE_OFC821_n425 FE_RN_39 n423 VDD VSS CKND2
XFE_OFC819_n904 n904 n335 VDD VSS INVD2
XFE_OFC815_shared_plane_22 value[22] FE_OFN83_shared_plane_22 VDD VSS INVD8
XFE_OFC814_shared_plane_22 value[22] n165 VDD VSS INVD8
XFE_OFC804_shared_plane_13 value[13] FE_OFN86_shared_plane_13 VDD VSS INVD6
XFE_OFC790_n87 n87 n88 VDD VSS CKND1
XFE_OFC789_n87 n87 n1144 VDD VSS CKND0
XFE_OFC787_n90 n90 n1135 VDD VSS INVD1
XFE_OFC743_n873 n873 n484 VDD VSS CKND4
XFE_OFC689_reciprocal_square_5 n767 FE_OFN2797_reciprocal_square_5 VDD VSS
+ CKBD1
XFE_OFC688_reciprocal_square_5 n350 FE_OFN2796_reciprocal_square_5 VDD VSS
+ CKND1
XFE_OFC687_reciprocal_square_5 n350 n808 VDD VSS CKND0
XFE_OFC686_reciprocal_square_5 n797 n767 VDD VSS CKND1
XFE_OFC685_reciprocal_square_5 n797 n574 VDD VSS CKND2
XFE_OFC684_reciprocal_square_5 n797 n350 VDD VSS CKND1
XFE_OFC683_reciprocal_square_5 n269 n704 VDD VSS BUFFD3
XFE_OFC682_reciprocal_square_5 coefficient[5] n797 VDD VSS CKND2
XFE_OFC681_reciprocal_square_5 coefficient[5] n269 VDD VSS CKBD1
XFE_OFC668_n127 n127 n1024 VDD VSS INVD4
XFE_OFC643_n192 n192 n119 VDD VSS INVD4
XFE_OFC621_n290 n290 n287 VDD VSS INVD4
XFE_OFC586_shared_plane_20 n40 FE_OFN2782_shared_plane_20 VDD VSS INVD4
XFE_OFC585_shared_plane_20 n40 n296 VDD VSS INVD6
XFE_OFC584_shared_plane_20 n40 n363 VDD VSS CKND4
XFE_OFC583_shared_plane_20 value[20] n40 VDD VSS INVD6
XFE_OFC571_shared_plane_26 n56 n55 VDD VSS INVD4
XFE_OFC570_shared_plane_26 n56 FE_OFN80_shared_plane_26 VDD VSS INVD8
XFE_OFC569_shared_plane_26 FE_OCPN1170_n56 n315 VDD VSS CKND1
XFE_OFC568_shared_plane_26 value[26] n56 VDD VSS INVD8
XFE_OFC488_reciprocal_square_4 FE_OFN2774_reciprocal_square_4
+ FE_OFN2776_reciprocal_square_4 VDD VSS CKND1
XFE_OFC487_reciprocal_square_4 n1002 FE_OFN2775_reciprocal_square_4 VDD VSS
+ BUFFD2
XFE_OFC486_reciprocal_square_4 n1002 FE_OFN2774_reciprocal_square_4 VDD VSS
+ CKND1
XFE_OFC485_reciprocal_square_4 n1002 n575 VDD VSS CKND1
XFE_OFC484_reciprocal_square_4 n1002 n278 VDD VSS CKND1
XFE_OFC483_reciprocal_square_4 n685 n842 VDD VSS CKND1
XFE_OFC482_reciprocal_square_4 n685 n923 VDD VSS CKND1
XFE_OFC481_reciprocal_square_4 n685 n758 VDD VSS CKND1
XFE_OFC480_reciprocal_square_4 n798 n1002 VDD VSS CKND1
XFE_OFC479_reciprocal_square_4 n798 n685 VDD VSS CKBD1
XFE_OFC478_reciprocal_square_4 coefficient[4] n798 VDD VSS CKND2
XFE_OFC477_reciprocal_square_4 coefficient[4] n951 VDD VSS CKBD1
XFE_OFC455_reciprocal_square_2 n585 FE_OFN2769_reciprocal_square_2 VDD VSS
+ CKBD1
XFE_OFC453_reciprocal_square_2 n1003 n398 VDD VSS INVD1
XFE_OFC452_reciprocal_square_2 n937 n800 VDD VSS CKBD1
XFE_OFC451_reciprocal_square_2 n937 n177 VDD VSS CKBD1
XFE_OFC447_reciprocal_square_2 n757 n891 VDD VSS CKND1
XFE_OFC439_shared_plane_16 value[16] FE_OFN84_shared_plane_16 VDD VSS INVD6
XFE_OFC437_shared_plane_0 n633 n310 VDD VSS CKND2
XFE_OFC436_shared_plane_0 value[0] n633 VDD VSS CKND2
XFE_OFC427_reciprocal_square_0 n922 FE_OFN2762_reciprocal_square_0 VDD VSS
+ CKND1
XFE_OFC426_reciprocal_square_0 n922 FE_OFN2761_reciprocal_square_0 VDD VSS
+ CKND1
XFE_OFC425_reciprocal_square_0 n922 FE_OFN2760_reciprocal_square_0 VDD VSS
+ CKND1
XFE_OFC424_reciprocal_square_0 n922 n845 VDD VSS CKND1
XFE_OFC422_reciprocal_square_0 n957 n922 VDD VSS CKND2
XFE_OFC420_reciprocal_square_0 n957 n938 VDD VSS CKND0
XFE_OFC418_reciprocal_square_0 n716 n679 VDD VSS CKND1
XFE_OFC417_reciprocal_square_0 coefficient[0] n716 VDD VSS CKND2
XFE_OFC412_n6 FE_OFN2756_n6 FE_OFN2758_n6 VDD VSS CKND1
XFE_OFC411_n6 FE_OFN2755_n6 FE_OFN2757_n6 VDD VSS INVD2
XFE_OFC410_n6 n410 FE_OFN2756_n6 VDD VSS INVD2
XFE_OFC409_n6 n410 FE_OFN2755_n6 VDD VSS CKND1
XFE_OFC408_n6 n318 n410 VDD VSS CKND2
XFE_OFC407_n6 n318 n321 VDD VSS CKND1
XFE_OFC406_n6 n318 n322 VDD VSS CKND1
XFE_OFC405_n6 n420 n319 VDD VSS CKBD1
XFE_OFC404_n6 n420 n318 VDD VSS INVD2
XFE_OFC403_n6 coefficient[1] n420 VDD VSS INVD1
XFE_OFC402_n6 coefficient[1] n121 VDD VSS CKND1
XFE_OFC401_n6 coefficient[1] n317 VDD VSS CKND1
XFE_OFC400_n6 coefficient[1] n316 VDD VSS CKND1
XFE_OFC363_shared_plane_6 FE_OFN89_shared_plane_6 n86 VDD VSS INVD6
XFE_OFC362_shared_plane_6 value[6] FE_OFN89_shared_plane_6 VDD VSS INVD8
XFE_OFC361_shared_plane_6 value[6] n720 VDD VSS BUFFD4
XFE_OFC358_reciprocal_square_3 n756 FE_OFN2748_reciprocal_square_3 VDD VSS
+ CKND1
XFE_OFC357_reciprocal_square_3 FE_OFN94_n958 FE_OFN2747_reciprocal_square_3 VDD
+ VSS CKND1
XFE_OFC356_reciprocal_square_3 FE_OFN94_n958 FE_OFN2746_reciprocal_square_3 VDD
+ VSS CKND2
XFE_OFC355_reciprocal_square_3 n890 n599 VDD VSS CKND1
XFE_OFC354_reciprocal_square_3 n890 n946 VDD VSS CKND2
XFE_OFC353_reciprocal_square_3 n890 n756 VDD VSS CKND1
XFE_OFC352_reciprocal_square_3 n662 FE_OFN94_n958 VDD VSS CKND2
XFE_OFC351_reciprocal_square_3 n662 n481 VDD VSS CKND1
XFE_OFC350_reciprocal_square_3 n662 n1051 VDD VSS CKND1
XFE_OFC349_reciprocal_square_3 n759 n890 VDD VSS CKBD1
XFE_OFC348_reciprocal_square_3 n759 n662 VDD VSS CKND2
XFE_OFC347_reciprocal_square_3 n759 n958 VDD VSS CKND1
XFE_OFC346_reciprocal_square_3 coefficient[3] n759 VDD VSS CKND2
XFE_OFC222_n445 n445 n444 VDD VSS CKND1
XFE_OFC214_shared_plane_10 n58 FE_OFN2734_shared_plane_10 VDD VSS CKND4
XFE_OFC213_shared_plane_10 n58 n57 VDD VSS INVD6
XFE_OFC212_shared_plane_10 value[10] n58 VDD VSS INVD6
XFE_OFC92_n60 value[17] FE_OFN92_n60 VDD VSS BUFFD4
XFE_OFC88_shared_plane_8 value[8] FE_OFN88_shared_plane_8 VDD VSS BUFFD8
XU4 FE_OCPN1182_n209 n25 VDD VSS CKBD1
XU5 FE_OCPN1308_n1016 n1015 n47 VDD VSS AN2D2
XU6 FE_RN_15 n1096 n179 VDD VSS ND2D4
XU8 n1078 n148 VDD VSS CKND6
XU10 n1099 FE_OCPN1522_n1098 n1100 VDD VSS CKND2D2
XU11 FE_RN_31 n1125 n230 VDD VSS NR2XD2
XU12 n1105 n1104 n1106 VDD VSS CKND2D4
XU13 n1102 n2 VDD VSS BUFFD2
XU14 FE_RN_29 n1095 VDD VSS INVD4
XU15 n1102 n1093 VDD VSS INVD4
XU16 n340 n1131 n1001 VDD VSS CKND2D4
XU17 n1089 n1088 n1125 VDD VSS NR2D3
XU18 n1092 n1103 VDD VSS BUFFD4
XU19 n1073 n1070 n1102 VDD VSS NR2XD4
XU20 n1016 n1015 n1070 VDD VSS NR2D8
XU22 n993 FE_OCPN1450_n992 n1154 VDD VSS CKND2D8
XU23 n1109 n1108 n1107 n1088 n1114 VDD VSS FA1D1
XU24 n997 n996 n206 VDD VSS ND2D8
XU25 n935 n934 n1160 VDD VSS ND2D4
XU26 n564 n1110 n1118 n1113 n1121 VDD VSS FA1D0
XU27 n11 n9 n1109 VDD VSS CKND2D1
XU28 n1185 n1190 n838 VDD VSS NR2XD2
XU30 n932 n237 VDD VSS INVD4
XU31 n834 n833 n1190 VDD VSS NR2XD2
XU32 n883 n882 n1180 VDD VSS ND2D4
XU33 n836 n835 n1185 VDD VSS NR2XD3
XU35 n1066 n12 n11 VDD VSS ND2D1
XU36 n865 n864 n863 n883 n884 VDD VSS FA1D4
XU37 FE_OCPN1277_n982 n488 VDD VSS INVD2
XU38 n974 n411 VDD VSS CKND2
XU39 n829 n828 n827 n834 n835 VDD VSS FA1D4
XU40 n981 n489 VDD VSS INVD2
XU41 n978 n19 VDD VSS BUFFD4
XU42 FE_OCPN1517_n28 n1049 n26 n1068 VDD VSS IOA21D2
XU43 n983 n499 VDD VSS CKND4
XU44 n955 n956 n470 VDD VSS NR2XD1
XU45 n1028 FE_OCPN1471_n1029 n494 VDD VSS ND2D2
XU46 n955 n956 n469 VDD VSS ND2D2
XU47 n984 n985 n497 VDD VSS ND2D1
XU49 n972 n971 n970 n991 n983 VDD VSS FA1D2
XU51 FE_OCPN1248_shared_plane_28 n756 n1063 VDD VSS ND2D3
XU52 FE_OCPN1576_n394 n442 VDD VSS INVD0
XU53 n1026 n99 n300 n1034 n1042 VDD VSS FA1D4
XU55 n1047 n282 VDD VSS CKND2
XU56 FE_OCPN1564_n4 n98 VDD VSS INVD1
XU57 n876 n435 VDD VSS CKND2
XU59 n172 n171 VDD VSS CKND4
XU60 n1029 n233 VDD VSS CKND2
XU61 n748 n747 n746 n715 n749 VDD VSS FA1D4
XU62 FE_OCPN1303_n905 FE_PSN1622_n906 n334 VDD VSS NR2XD3
XU63 n208 n466 VDD VSS INVD1
XU64 n244 n698 VDD VSS INVD2
XU65 n207 n948 n465 VDD VSS ND2D3
XU66 n462 n461 n751 VDD VSS ND2D4
XU67 n782 n781 n791 VDD VSS ND2D2
XU68 n205 n24 n23 VDD VSS ND2D1
XU69 n22 n326 n21 VDD VSS ND2D1
XU70 FE_OCPN1561_n745 n744 n743 n462 VDD VSS OAI21D2
XU71 n496 n22 VDD VSS INVD1
XU72 FE_OCPN1405_n822 n407 VDD VSS CKND2
XU73 n862 n449 VDD VSS CKND4
XU74 FE_OCPN3471_shared_plane_25 n951 n300 VDD VSS AN2XD1
XU75 n861 n448 VDD VSS INVD1
XU76 n697 n354 VDD VSS INVD4
XU77 n872 n483 VDD VSS INVD2
XU79 n678 n677 n1232 VDD VSS CKND2D2
XU80 n678 n677 n1231 VDD VSS NR2D3
XU81 n132 n130 n925 VDD VSS ND2D2
XU83 n76 FE_OFN2762_reciprocal_square_0 n968 VDD VSS AN2D4
XU84 FE_OCPN1521_shared_plane_27 n585 n99 VDD VSS AN2D4
XU85 n120 n416 n219 VDD VSS CKND2D2
XU86 n777 n776 n775 n785 n821 VDD VSS FA1D4
XU88 FE_OCPN1236_shared_plane_19 n800 n549 VDD VSS AN2D4
XU89 FE_OCPN1273_shared_plane_17 n939 n529 VDD VSS AN2D4
XU90 FE_RN_23 FE_RN_19 n247 VDD VSS INR2XD1
XU93 n165 n758 n220 VDD VSS CKND2D4
XU94 n823 n408 VDD VSS CKND4
XU95 n1026 n248 VDD VSS INVD2
XU96 n75 FE_OFN3492_n599 n396 VDD VSS CKND2D4
XU97 n966 n120 VDD VSS CKND4
XU98 n122 n940 n139 VDD VSS ND2D4
XU99 n858 n859 n476 VDD VSS NR2XD1
XU100 value[26] FE_OFN3479_FE_OFN2762_reciprocal_square_0 n468 VDD VSS CKND2D4
XU101 n894 n895 n265 VDD VSS NR2XD1
XU102 n741 n742 n400 VDD VSS CKND2D1
XU104 n1024 n560 n1023 n1035 n1044 VDD VSS FA1D4
XU105 n96 n542 n510 n876 n894 VDD VSS FA1D4
XU108 FE_RN_23 n387 VDD VSS INVD1
XU109 n225 n213 VDD VSS CKND2
XU111 FE_OFN81_shared_plane_25 n756 n164 VDD VSS CKND2D4
XU112 n193 n280 VDD VSS INVD2
XU113 FE_RN_4 FE_OFN2797_reciprocal_square_5 n426 VDD VSS ND2D4
XU114 n75 FE_OFN2761_reciprocal_square_0 n493 VDD VSS ND2D4
XU115 n57 FE_OFN2797_reciprocal_square_5 n513 VDD VSS AN2D4
XU117 n71 n177 n760 VDD VSS AN2D2
XU118 n665 n663 n664 n658 VDD VSS XOR3D1
XU119 n70 n897 n547 VDD VSS AN2D4
XU120 n71 n870 n548 VDD VSS AN2D2
XU121 n877 n878 n434 VDD VSS NR2XD1
XU123 value[17] n923 n453 VDD VSS ND2D2
XU125 n741 n742 n403 VDD VSS NR2XD1
XU126 n428 n427 n193 VDD VSS ND2D2
XU127 n591 n590 n152 n198 VDD VSS XNR3D4
XU129 FE_RN_4 n15 n367 VDD VSS ND2D4
XU130 n243 n700 n137 n242 VDD VSS XNR3D4
XU131 FE_OCPN7_n178 FE_OFN2769_reciprocal_square_2 n473 VDD VSS CKND2D8
XU132 n146 n952 n6 VDD VSS ND2D2
XU133 n525 n875 n518 n878 n892 VDD VSS FA1D4
XU135 n589 n152 VDD VSS CKND2
XU136 FE_OCPN1236_shared_plane_19 FE_OFN2760_reciprocal_square_0 n284 VDD VSS
+ ND2D4
XU137 n296 n939 n428 VDD VSS CKND2D4
XU138 n270 n360 n268 n710 VDD VSS XOR3D2
XU139 FE_OFN2757_n6 n168 n950 VDD VSS INR2D4
XU140 FE_RN_9 FE_OFN2747_reciprocal_square_3 n480 VDD VSS CKND2D4
XU141 n949 n421 VDD VSS CKND2
XU142 n61 n365 n427 VDD VSS CKND2D4
XU143 n62 n940 n916 VDD VSS ND2D4
XU144 n736 n444 n443 VDD VSS CKND2D2
XU145 n70 n842 n487 VDD VSS AN2D4
XU147 n38 FE_OFN2797_reciprocal_square_5 n762 VDD VSS AN2D4
XU148 n897 n311 n525 VDD VSS INR2D4
XU149 n841 n875 VDD VSS CKND2
XU150 n736 n275 VDD VSS CKND4
XU151 FE_OCPN1273_shared_plane_17 n365 n458 VDD VSS ND2D2
XU152 n870 n258 n518 VDD VSS INR2XD1
XU153 n319 n204 n843 VDD VSS INR2D2
XU155 n165 FE_OFN2769_reciprocal_square_2 n917 VDD VSS ND2D8
XU156 n46 n15 VDD VSS INVD1
XU157 n122 n365 n214 VDD VSS ND2D4
XU158 n57 n891 n515 VDD VSS AN2D1
XU159 n689 n690 n463 VDD VSS CKND2D2
XU160 n661 n556 n660 n667 n689 VDD VSS FA1D4
XU161 value[15] n258 VDD VSS INVD6
XU162 FE_OFN88_shared_plane_8 FE_OFN2757_n6 n103 VDD VSS AN2D4
XU164 n279 n523 VDD VSS CKND2
XU165 n617 n616 n615 n650 n608 VDD VSS FA1D1
XU167 n277 n690 VDD VSS CKND2
XU168 n66 n67 VDD VSS INVD6
XU170 n1045 n46 VDD VSS INVD1
XU175 value[4] n254 n253 VDD VSS ND2D3
XU176 FE_OFN86_shared_plane_13 n845 n445 VDD VSS ND2D2
XU177 value[11] n66 VDD VSS CKND8
XU178 n767 n37 n559 VDD VSS INR2XD1
XU180 n840 n1046 VDD VSS BUFFD1
XU182 n594 n593 n592 n617 n576 VDD VSS FA1D2
XU183 n399 n37 n555 VDD VSS INR2XD1
XU185 n121 n37 n625 VDD VSS INR2XD1
XU186 FE_OFN88_shared_plane_8 n297 VDD VSS CKND12
XU187 n101 n506 n603 n594 VDD VSS HA1D1
XU189 value[5] n446 n270 VDD VSS CKND2D3
XU190 value[1] FE_OFN2746_reciprocal_square_3 n102 VDD VSS AN2XD1
XU192 n509 n504 n593 n568 VDD VSS HA1D1
XU194 value[1] n574 n256 VDD VSS CKND2D1
XU196 n981 FE_OCPN1277_n982 n490 VDD VSS NR2XD1
XU197 n493 n563 VDD VSS CKND4
XU198 n126 n237 n194 VDD VSS CKND2D4
XU200 n486 n485 n551 VDD VSS CKND2D4
XU201 n363 n365 n364 VDD VSS ND2D3
XU202 FE_OCPN1236_shared_plane_19 n322 n550 VDD VSS AN2D4
XU204 n367 n83 n106 VDD VSS AN2D4
XU205 n283 n3 n980 VDD VSS ND2D2
XU206 n926 n925 n3 VDD VSS ND2D1
XU207 n877 n878 n435 n881 VDD VSS XNR3D4
XU208 n76 FE_OFN3491_n420 n208 VDD VSS ND2D4
XU212 n71 n898 n841 VDD VSS CKND2D2
XU213 n225 n214 n223 VDD VSS ND2D2
XU214 n916 n944 VDD VSS CKND4
XU215 n4 n14 n1066 n1086 VDD VSS XOR3D2
XU216 n55 coefficient[6] n4 VDD VSS ND2D2
XU217 n742 n741 n740 n743 VDD VSS XOR3D2
XU218 value[27] n78 VDD VSS INVD8
XU219 n495 n146 VDD VSS CKND2
XU221 n124 n2 n129 VDD VSS ND2D4
XU223 n1065 n1045 VDD VSS CKND3
XU226 n100 n1087 n1086 n1081 n1107 VDD VSS FA1D1
XU228 n5 n952 VDD VSS INVD8
XU229 FE_RN_30 n758 n5 VDD VSS CKND2D8
XU230 n455 n454 VDD VSS CKND2
XU232 FE_OCPN4_shared_plane_25 n1119 n14 VDD VSS ND2D3
XU233 n1039 n1040 n1071 VDD VSS ND2D4
XU234 FE_OFN3489_n269 n168 n1023 VDD VSS INR2XD1
XU235 n995 n994 n1149 VDD VSS NR2XD4
XU237 n54 n1045 n394 VDD VSS ND2D4
XU238 n7 n233 n232 VDD VSS CKND2D2
XU239 n1028 n7 VDD VSS CKND4
XU240 n8 n1032 VDD VSS INVD4
XU241 FE_OFN80_shared_plane_26 n756 n8 VDD VSS ND2D4
XU242 n394 n236 n1047 n1069 VDD VSS XNR3D4
XU243 n1046 n1025 VDD VSS INVD1
XU244 FE_OCPN1184_FE_OFN80_shared_plane_26 n704 n1047 VDD VSS ND2D4
XU246 FE_RN_34 FE_OFN3490_n398 n203 VDD VSS CKND2D4
XU247 n984 n985 n498 VDD VSS NR2XD1
XU249 FE_RN_15 n1079 n149 VDD VSS ND2D4
XU252 n1039 n1040 n1073 VDD VSS NR2XD4
XU253 n704 FE_OFN2806_shared_plane_25 n28 VDD VSS INR2XD2
XU254 FE_RN_7 FE_OFN3479_FE_OFN2762_reciprocal_square_0 n1026 VDD VSS ND2D4
XU255 n10 n98 n9 VDD VSS CKND2D0
XU256 n14 n10 VDD VSS INVD0
XU257 n13 n14 n12 VDD VSS CKND2D0
XU258 n98 n13 VDD VSS INVD0
XU259 n29 n208 n948 n285 VDD VSS XNR3D4
XU261 n1 FE_OFN2758_n6 n424 VDD VSS CKND2D4
XU262 n367 FE_RN_24 n366 n216 VDD VSS XNR3D4
XU263 n16 n108 VDD VSS INVD4
XU264 n54 FE_OFN2761_reciprocal_square_0 n16 VDD VSS ND2D4
XU266 n341 n209 n178 VDD VSS ND2D4
XU267 n473 n969 n968 n984 VDD VSS XNR3D4
XU268 n442 n441 n17 n1087 VDD VSS IOA21D2
XU269 n282 n235 n17 VDD VSS ND2D2
XU270 n1077 n1076 n1098 VDD VSS ND2D4
XU271 FE_OCPN1396_FE_OFN83_shared_plane_22 n1025 n83 VDD VSS ND2D4
XU272 n18 n162 VDD VSS INVD6
XU273 n721 FE_RN_4 n18 VDD VSS IND2D4
XU274 n1041 FE_OCPN1309_n1071 n511 VDD VSS ND2D2
XU275 n965 n219 n415 VDD VSS CKND2D4
XU276 FE_RN_42 n758 n949 VDD VSS ND2D8
XU277 n396 n220 n395 n965 VDD VSS XNR3D4
XU281 n987 n988 n986 n993 n994 VDD VSS FA1D4
XU282 FE_OCPN5_shared_plane_24 n1025 n496 VDD VSS ND2D4
XU285 FE_OCPN1443_n1070 n1022 VDD VSS INVD2
XU287 n881 n880 n879 n885 n886 VDD VSS FA1D4
XU291 n1018 n936 n331 n1130 VDD VSS AOI21D4
XU292 FE_RN_26 n20 n169 VDD VSS ND2D3
XU293 n949 n947 n217 n978 VDD VSS XNR3D4
XU295 FE_RN_42 n599 n942 VDD VSS ND2D4
XU296 n78 n318 n1008 VDD VSS NR2XD3
XU297 n23 n21 n1062 VDD VSS ND2D2
XU298 n496 n1052 n24 VDD VSS CKND2D2
XU300 FE_RN_42 FE_OFN2769_reciprocal_square_2 n175 VDD VSS CKND2D4
XU301 n1158 n1159 n936 VDD VSS NR2XD2
XU302 FE_RN_22 n1164 n1158 VDD VSS ND2D2
XU303 n81 n563 n921 n919 n982 VDD VSS FA1D4
XU304 n194 n178 n221 VDD VSS ND2D3
XU305 n27 n1048 n26 VDD VSS IND2D2
XU306 n28 n1049 n27 VDD VSS NR2XD1
XU307 n1049 n28 n1048 n1055 VDD VSS XOR3D2
XU308 n174 n175 n139 n176 n971 VDD VSS OAI22D2
XU309 n468 n29 VDD VSS CKND4
XU310 FE_RN_30 n317 n562 VDD VSS AN2D4
XU312 n230 n191 n228 VDD VSS ND2D2
XU313 n284 n287 n850 n861 VDD VSS XNR3D4
XU316 n411 FE_RN_2 n32 n975 VDD VSS XOR3D2
XU317 FE_RN_6 n32 VDD VSS CKND2
XU318 FE_RN_37 FE_OFN3489_n269 n107 VDD VSS AN2D4
XU319 n267 n494 n1057 VDD VSS ND2D3
XU322 FE_OCPN4_shared_plane_25 FE_OFN3414_reciprocal_square_6 n236 VDD VSS
+ ND2D4
XU323 value[22] FE_OFN2755_n6 n81 VDD VSS NR2D4
XU324 value[27] n951 n1050 VDD VSS ND2D1
XU326 n232 n1027 n267 VDD VSS ND2D2
XU327 n1032 n1033 n1031 n1028 n1054 VDD VSS FA1D4
XU328 n1102 n376 n1222 VDD VSS ND2D3
XU329 n1227 n1078 VDD VSS INVD4
XU330 n75 FE_OFN3477_n1025 n560 VDD VSS AN2D4
XU331 n1149 n1147 n1131 VDD VSS NR2XD4
XU332 n140 n993 n1147 VDD VSS INR2D4
XU333 n562 n108 n967 n981 n985 VDD VSS FA1D4
XU335 n78 FE_OFN2748_reciprocal_square_3 n1049 VDD VSS NR2XD3
XU337 n973 n293 VDD VSS INVD4
XU340 n297 n33 VDD VSS INVD6
XU341 n33 n34 VDD VSS CKND6
XU354 n1222 n1116 n1117 VDD VSS NR2XD4
XU356 FE_OCPN1145_n1170 FE_OCPN1261_n551 n1171 VDD VSS ND2D1
XU357 n364 n162 n107 n45 VDD VSS XNR3D4
XU358 n766 FE_OCPN1577_n112 n262 n261 VDD VSS OAI21D2
XU359 n895 n894 n210 n914 VDD VSS XNR3D4
XU361 FE_OCPN1512_n858 FE_OCPN1602_n859 n474 VDD VSS ND2D1
XU362 n1038 n1037 n1036 n1016 n1039 VDD VSS FA1D4
XU363 n70 n946 n799 VDD VSS CKND2D2
XU364 n1013 n1014 n1012 n998 n1015 VDD VSS FA1D4
XU365 n258 n48 VDD VSS CKND4
XU366 value[1] n49 VDD VSS INVD3
XU367 n49 n50 VDD VSS CKND4
XU372 n66 n68 VDD VSS INVD4
XU374 n69 n71 VDD VSS INVD4
XU376 n78 n79 VDD VSS CKND6
XU377 FE_OCPN1238_n178 n1045 n1052 VDD VSS CKND2D4
XU378 n79 FE_OFN3479_FE_OFN2762_reciprocal_square_0 n109 VDD VSS AN2D4
XU379 n370 n958 n531 VDD VSS AN2XD1
XU380 n1205 n1210 n356 n753 VDD VSS OAI21D4
XU382 FE_OFN1353_shared_plane_22 FE_OFN3477_n1025 n231 VDD VSS ND2D4
XU383 n71 n845 n717 VDD VSS AN2D2
XU384 FE_OCPN3473_n79 n1119 n564 VDD VSS CKAN2D1
XU385 FE_OCPN3473_n79 coefficient[6] n1084 VDD VSS CKND2D1
XU386 FE_RN_31 n1079 VDD VSS CKND4
XU387 n750 n749 n1210 VDD VSS ND2D4
XU388 n788 n787 n786 n752 n789 VDD VSS FA1D4
XU389 n520 n763 n762 n761 n766 VDD VSS FA1D4
XU391 n1094 n1104 VDD VSS BUFFD2
XU392 n1095 n1103 n1104 n192 VDD VSS OAI21D4
XU393 n1151 FE_OCPN1282_n1150 n1152 VDD VSS ND2D1
XU397 n161 n107 n160 VDD VSS ND2D2
XU398 n162 n364 n161 VDD VSS IND2D2
XU399 n802 n801 n546 n822 n826 VDD VSS FA1D1
XU400 n530 n517 n853 n858 n854 VDD VSS FA1D4
XU401 FE_OCPN1186_n1134 n90 VDD VSS CKND2
XU402 n960 n390 VDD VSS INVD2
XU403 FE_OCPN1171_n206 n92 VDD VSS INVD1
XU404 n92 n93 VDD VSS CKND2
XU405 n48 n177 n519 VDD VSS AN2D4
XU408 n54 FE_OFN3492_n599 n495 VDD VSS CKND2D8
XU409 n76 FE_OFN3490_n398 n141 VDD VSS ND2D4
XU411 FE_OFN92_n60 n317 n530 VDD VSS AN2D4
XU412 FE_OFN92_n60 n800 n290 VDD VSS ND2D3
XU413 FE_OFN92_n60 n940 n136 VDD VSS ND2D3
XU414 n839 n1065 VDD VSS CKBD1
XU415 n263 n262 VDD VSS CKND2
XU416 n392 n410 n583 VDD VSS AN2XD1
XU418 FE_OCPN1163_n341 FE_OCPN1524_FE_RN_22 n1020 VDD VSS ND2D1
XU419 FE_OFN88_shared_plane_8 n399 n95 VDD VSS AN2D4
XU420 value[17] n946 n96 VDD VSS AN2D4
XU425 n392 n679 n97 VDD VSS AN2XD1
XU426 FE_OCPN3473_n79 n704 n100 VDD VSS CKAN2D1
XU427 value[1] FE_OFN2775_reciprocal_square_4 n101 VDD VSS AN2D2
XU428 n122 n923 n104 VDD VSS AN2D4
XU429 n364 n959 VDD VSS INVD1
XU431 FE_RN_13 n220 n110 VDD VSS AN2D4
XU432 n47 n294 VDD VSS INVD2
XU433 n1095 n320 VDD VSS INVD4
XU435 FE_OFN2734_shared_plane_10 n679 n113 VDD VSS AN2XD1
XU436 FE_OFN2734_shared_plane_10 n958 n125 VDD VSS ND2D2
XU437 FE_OFN2734_shared_plane_10 n805 n114 VDD VSS AN2D4
XU438 n57 FE_OFN2776_reciprocal_square_4 n116 VDD VSS AN2D4
XU439 n1204 n754 n753 n1195 VDD VSS AOI21D4
XU440 n1205 n1209 n754 VDD VSS NR2XD2
XU441 n930 n238 VDD VSS CKND2
XU442 n329 n328 n928 VDD VSS CKND2D2
XU443 n878 n877 n432 n904 VDD VSS IOA21D2
XU444 n289 n286 n873 VDD VSS ND2D3
XU446 FE_OCPN1303_n905 n333 VDD VSS INVD2
XU448 n508 n133 n132 VDD VSS ND2D1
XU449 n744 n382 VDD VSS CKND2
XU450 n899 n212 VDD VSS INVD4
XU451 n134 n131 VDD VSS INVD1
XU452 n384 n383 n744 VDD VSS ND2D2
XU453 n717 n765 n764 n788 n778 VDD VSS FA1D1
XU454 n727 n726 n725 n748 n740 VDD VSS FA1D2
XU455 n487 n158 VDD VSS INVD0
XU456 n772 n116 n404 VDD VSS ND2D2
XU459 n656 n655 n611 VDD VSS NR2D2
XU462 n243 n524 VDD VSS INVD1
XU463 n647 n646 n554 VDD VSS OR2D1
XU464 n185 n183 n571 VDD VSS CKND2D1
XU465 n186 n567 n185 VDD VSS ND2D1
XU466 n184 n568 n183 VDD VSS ND2D0
XU467 n768 n37 n553 VDD VSS INR2D0
XU468 n568 n188 n567 n597 VDD VSS XNR3D2
XU469 n257 n349 VDD VSS INVD0
XU470 n310 FE_OFN2775_reciprocal_square_4 n507 VDD VSS CKAN2D1
XU474 n734 n805 VDD VSS INVD0
XU475 n1065 n1119 VDD VSS INVD1
XU479 n1093 n1103 n1096 VDD VSS NR2D3
XU480 n1161 n1160 n1162 VDD VSS CKND2D0
XU481 n1183 n1182 scaled_value[11] VDD VSS XNR2D2
XU482 n1177 n1176 n1178 VDD VSS CKND2D1
XU483 n330 n908 n328 VDD VSS ND2D1
XU484 n155 n487 n154 VDD VSS ND2D2
XU485 n440 n439 VDD VSS INVD2
XU487 n739 FE_PSN1639_n738 n383 VDD VSS ND2D2
XU488 n48 FE_OFN2747_reciprocal_square_3 n159 VDD VSS CKND2D4
XU489 n68 n768 n538 VDD VSS AN2XD1
XU490 n703 n359 VDD VSS CKND1
XU491 n188 n187 n186 VDD VSS CKND2D0
XU492 n573 n349 n348 VDD VSS IND2D1
XU493 n188 n184 VDD VSS INVD0
XU494 n310 FE_OFN2746_reciprocal_square_3 n501 VDD VSS CKAN2D1
XU497 n229 n1129 n227 VDD VSS CKND2D2
XU498 n1163 n1162 scaled_value[16] VDD VSS XNR2D2
XU499 n1166 n1165 scaled_value[14] VDD VSS CKXOR2D4
XU500 n1164 n1019 VDD VSS INVD0
XU501 FE_OCPN1183_n1164 n25 n1165 VDD VSS CKND2D1
XU502 n1223 n1224 VDD VSS INVD1
XU503 FE_OCPN1151_n1175 n1177 VDD VSS INVD1
XU504 n1121 n1120 n1223 VDD VSS ND2D1
XU505 n1192 FE_OCPN1596_n1191 n1193 VDD VSS CKND2D0
XU506 n418 n416 VDD VSS CKND2
XU507 FE_OFN2775_reciprocal_square_4 n56 n205 VDD VSS INR2XD2
XU508 n894 n895 n266 VDD VSS CKND2D1
XU510 n288 FE_OCPN1572_n287 n286 VDD VSS ND2D1
XU512 n156 n154 n855 VDD VSS CKND2D2
XU513 FE_OCPN1280_n774 n362 FE_OCPN1533_n773 n361 VDD VSS OAI21D2
XU514 n545 n157 n156 VDD VSS CKND2D2
XU515 FE_OFN92_n60 FE_OFN2760_reciprocal_square_0 n820 VDD VSS AN2D2
XU516 n487 n159 n545 n847 VDD VSS XNR3D2
XU517 n766 FE_OCPN1577_n112 n260 VDD VSS ND2D1
XU518 n893 n547 n541 n895 n896 VDD VSS FA1D4
XU519 FE_OFN1378_n272 n478 n477 VDD VSS ND2D1
XU520 FE_OFN2766_shared_plane_16 n870 n541 VDD VSS AN2D4
XU521 n68 n805 n533 VDD VSS AN2D2
XU522 n242 n241 VDD VSS INVD0
XU523 FE_OCPN1258_n480 n479 VDD VSS CKND2
XU524 FE_OFN86_shared_plane_13 n177 n272 VDD VSS AN2D4
XU525 FE_OCPN1599_FE_OFN86_shared_plane_13 n870 n271 VDD VSS AN2XD1
XU526 n590 n142 VDD VSS INVD2
XU527 n190 n189 n682 VDD VSS CKND2D1
XU528 n591 n143 VDD VSS CKND2
XU529 n583 n582 n581 n590 n664 VDD VSS FA1D2
XU530 n673 n103 n189 VDD VSS CKND2D0
XU531 n97 n610 n609 n655 n591 VDD VSS FA1D4
XU532 n700 n524 n251 VDD VSS CKND2D1
XU533 n667 n586 n666 n663 n684 VDD VSS FA1D1
XU534 n312 n668 n257 VDD VSS AN2XD1
XU535 n50 FE_OFN3414_reciprocal_square_6 n566 VDD VSS AN2D4
XU539 n1230 FE_OCPN1458_n191 n1229 scaled_value[28] VDD VSS AOI21D4
XU542 n1179 n1178 scaled_value[12] VDD VSS CKXOR2D4
XU543 n1189 n1188 scaled_value[10] VDD VSS XNR2D2
XU544 n1194 n1193 scaled_value[9] VDD VSS CKXOR2D4
XU545 n500 n1223 n1122 VDD VSS ND2D1
XU546 n1208 n1207 scaled_value[6] VDD VSS XNR2D0
XU547 n1203 n1202 scaled_value[7] VDD VSS XNR2D2
XU548 n1011 n215 VDD VSS CKND2
XU549 n1206 FE_OCPN1168_n356 n1207 VDD VSS CKND2D1
XU550 FE_OCPN3450_shared_plane_28 n704 n1085 VDD VSS ND2D1
XU552 FE_OCPN3450_shared_plane_28 n1119 n1120 VDD VSS ND2D1
XU554 n1220 n1219 scaled_value[3] VDD VSS XNR2D1
XU555 FE_OCPN1213_n1205 n1206 VDD VSS INVD1
XU557 FE_OCPN1259_n785 n783 n784 n782 VDD VSS OAI21D1
XU558 n476 n475 VDD VSS INVD1
XU559 n423 n422 n245 VDD VSS CKND2D2
XU560 n783 FE_OCPN1259_n785 n781 VDD VSS CKND2D1
XU561 FE_RN_7 n410 n1033 VDD VSS ND2D4
XU562 FE_OCPN3450_shared_plane_28 n951 n1066 VDD VSS ND2D2
XU563 n1233 FE_OCPN1530_n1232 n1235 VDD VSS CKND2D1
XU564 FE_OCPN1502_n352 FE_OCPN1252_n244 n1220 VDD VSS CKND2D1
XU565 n131 n135 n130 VDD VSS CKND2D1
XU566 n134 n136 n133 VDD VSS ND2D1
XU567 n1242 n249 scaled_value[0] VDD VSS CKXOR2D1
XU568 FE_PSN1646_n534 n479 n477 n810 VDD VSS IOA21D2
XU569 n261 n260 n823 VDD VSS ND2D2
XU570 n816 n439 n438 n819 VDD VSS IOA21D1
XU572 n158 n159 n157 VDD VSS ND2D1
XU575 n369 n733 n368 n765 VDD VSS IOA21D2
XU576 n439 n816 n760 n438 VDD VSS OAI21D1
XU577 n804 n803 n378 n813 VDD VSS IOA21D2
XU578 FE_PSN1646_n534 FE_OCPN1258_n480 n478 VDD VSS IND2D4
XU579 FE_OFN2766_shared_plane_16 FE_OFN2758_n6 n544 VDD VSS AN2D4
XU580 n535 n379 n378 VDD VSS ND2D2
XU581 n729 n537 n728 n741 n774 VDD VSS FA1D4
XU583 FE_OFN2766_shared_plane_16 n897 n540 VDD VSS AN2D4
XU584 FE_OFN85_shared_plane_16 n177 n545 VDD VSS AN2D2
XU585 n533 n846 n271 n849 n850 VDD VSS FA1D4
XU586 n682 n339 VDD VSS INVD0
XU587 n708 n538 n707 n713 n739 VDD VSS FA1D2
XU588 n67 FE_OFN2776_reciprocal_square_4 n534 VDD VSS AN2D4
XU589 n683 n684 n338 VDD VSS NR2XD0
XU590 n590 n591 n429 VDD VSS CKND2D1
XU591 n710 n709 n532 n706 n738 VDD VSS FA1D1
XU592 n683 n684 n337 VDD VSS CKND2D1
XU593 n804 n380 VDD VSS INVD1
XU594 n95 n681 n680 n683 n707 VDD VSS FA1D2
XU595 n719 n718 n522 n730 n733 VDD VSS FA1D4
XU596 n359 n358 n702 n357 VDD VSS IOA21D2
XU598 n343 n342 n606 VDD VSS ND2D2
XU599 n345 n344 n612 n343 VDD VSS IOA21D2
XU600 n620 n619 n618 n647 n612 VDD VSS FA1D2
XU601 n613 n614 n342 VDD VSS CKND2D1
XU602 n555 n622 n621 n646 n614 VDD VSS FA1D1
XU603 n632 n637 n636 n640 VDD VSS AOI21D0
XU604 n323 n768 n512 VDD VSS CKAN2D0
XU605 n50 n312 VDD VSS BUFFD4
XU606 n50 n420 n195 VDD VSS AN2XD1
XU607 n310 n585 n505 VDD VSS CKAN2D1
XU608 n310 n668 n503 VDD VSS CKAN2D1
XU611 n1227 n1116 n1115 n153 VDD VSS OAI21D4
XU612 n1142 n1141 scaled_value[20] VDD VSS CKXOR2D4
XU614 n1153 n1152 scaled_value[18] VDD VSS CKXOR2D2
XU615 n1157 n1156 scaled_value[17] VDD VSS XNR2D2
XU616 n1166 n1019 n25 n1021 VDD VSS OAI21D1
XU618 n1221 n500 n1228 VDD VSS CKND2D1
XU619 n1225 n500 n1224 n1226 VDD VSS AOI21D1
XU620 n1172 n1171 scaled_value[13] VDD VSS CKXOR2D2
XU621 n1090 n1124 n1091 VDD VSS ND2D1
XU622 n1128 n1127 n1129 VDD VSS ND2D1
XU623 n992 n140 VDD VSS CKND4
XU624 n1126 n1128 VDD VSS INVD1
XU625 n1055 n1054 n1053 n1056 n1059 VDD VSS FA1D1
XU626 n1089 n1088 n1124 VDD VSS ND2D2
XU627 n1114 n1113 n1126 VDD VSS NR2D2
XU628 n1114 n1113 n1127 VDD VSS ND2D1
XU629 n1082 n1081 n1080 n1076 n1089 VDD VSS FA1D4
XU630 n215 n181 VDD VSS INVD4
XU631 n374 n373 VDD VSS INVD2
XU633 n1213 n1212 scaled_value[5] VDD VSS CKXOR2D1
XU635 n1064 n1063 n1062 n1067 n1082 VDD VSS FA1D1
XU636 n914 n913 n912 n887 n930 VDD VSS FA1D4
XU637 n834 n833 n1191 VDD VSS ND2D4
XU638 n968 n413 n412 VDD VSS ND2D2
XU639 n1112 n1111 n1085 n1108 n1118 VDD VSS FA1D1
XU640 FE_OCPN1538_n980 n491 VDD VSS INVD1
XU641 FE_OCPN3450_shared_plane_28 coefficient[6] n1110 VDD VSS ND2D1
XU642 n414 n413 VDD VSS INVD2
XU643 n265 n210 n266 n907 VDD VSS OAI21D2
XU646 n266 n210 n265 n264 VDD VSS AOI21D1
XU647 n857 n475 n437 VDD VSS ND2D2
XU648 n1216 n1215 n1218 VDD VSS CKND2D1
XU649 n752 n751 n1205 VDD VSS NR2XD4
XU650 n1235 n1234 scaled_value[2] VDD VSS XOR2D0
XU652 n1238 n1237 scaled_value[1] VDD VSS XNR2D1
XU653 FE_OCPN1511_n1052 n326 VDD VSS INVD1
XU654 n856 n855 n854 n865 n871 VDD VSS FA1D2
XU655 n259 n197 VDD VSS INVD2
XU657 n405 n404 n776 VDD VSS CKND2D3
XU658 n820 n819 n818 n829 n857 VDD VSS FA1D2
XU659 n453 n452 VDD VSS CKND2
XU660 n715 n714 n1215 VDD VSS ND2D4
XU661 n826 n825 n824 n827 n867 VDD VSS FA1D4
XU662 n540 n529 n915 n926 n972 VDD VSS FA1D1
XU664 n780 n779 n778 n784 n831 VDD VSS FA1D4
XU666 n900 n539 n104 n902 n921 VDD VSS FA1D4
XU667 n223 n222 VDD VSS CKND2
XU668 n811 n810 n809 n832 n824 VDD VSS FA1D4
XU669 n676 n675 n674 n659 n677 VDD VSS FA1D4
XU670 n241 n706 n239 n747 VDD VSS IOA21D1
XU671 n1241 n1240 n1242 VDD VSS CKND2D1
XU672 n713 n712 n711 n697 n714 VDD VSS FA1D4
XU673 n218 n451 VDD VSS CKND2
XU674 n696 n353 VDD VSS INVD1
XU675 n176 n139 n174 VDD VSS CKAN2D1
XU676 n430 n429 n674 VDD VSS CKND2D2
XU677 n695 n694 n693 n678 n696 VDD VSS FA1D2
XU678 n526 n817 n519 n818 n848 VDD VSS FA1D4
XU679 n240 FE_OCPN1284_n242 n705 n239 VDD VSS IOA21D1
XU680 n114 n815 n814 n812 n853 VDD VSS FA1D4
XU682 n589 n431 n430 VDD VSS ND2D2
XU683 n339 n338 n337 n712 VDD VSS OAI21D1
XU684 n536 n527 n761 n773 n780 VDD VSS FA1D4
XU685 n852 n528 n548 n856 n874 VDD VSS FA1D1
XU686 n692 n691 n113 n695 n705 VDD VSS FA1D1
XU687 n665 n664 n388 n694 VDD VSS IOA21D1
XU688 n125 n514 VDD VSS INVD1
XU689 n706 n240 VDD VSS INVD1
XU690 n409 n729 VDD VSS INVD4
XU691 n611 n200 VDD VSS INVD1
XU692 n143 n142 n431 VDD VSS CKND2D2
XU693 n658 n202 VDD VSS INVD1
XU694 n351 n199 VDD VSS CKND2
XU695 n656 n655 n351 VDD VSS ND2D2
XU696 n664 n665 n663 n388 VDD VSS OAI21D1
XU697 n608 n607 n606 n656 n657 VDD VSS FA1D2
XU698 n580 n579 n578 n589 n676 VDD VSS FA1D2
XU699 n360 n703 n357 n731 VDD VSS IOA21D2
XU702 n571 n570 n569 n578 n673 VDD VSS FA1D1
XU703 n700 n524 n252 VDD VSS OR2D1
XU704 n671 n670 n669 n672 n680 VDD VSS FA1D1
XU705 n596 n597 n595 n607 n579 VDD VSS FA1D1
XU706 n268 n702 VDD VSS INVD1
XU707 n392 n399 n586 VDD VSS AN2XD1
XU708 FE_OFN3413_shared_plane_7 n842 n243 VDD VSS CKND2D4
XU709 n552 n687 n686 n681 n700 VDD VSS FA1D4
XU710 n614 n344 VDD VSS INVD1
XU711 n270 n703 VDD VSS INVD1
XU712 n613 n614 n346 VDD VSS CKXOR2D1
XU713 n613 n345 VDD VSS INVD1
XU714 n641 n640 n639 n502 VDD VSS OA21D0
XU715 n559 n588 n587 n580 n666 VDD VSS FA1D2
XU716 n360 n358 VDD VSS INVD1
XU717 n558 n601 n600 n613 n610 VDD VSS FA1D4
XU718 n557 n577 n576 n609 n582 VDD VSS FA1D1
XU719 n625 n624 n623 n643 n618 VDD VSS FA1D1
XU720 n253 n687 VDD VSS INVD2
XU721 n512 n635 n632 VDD VSS OR2D0
XU722 n573 n257 n347 VDD VSS CKND2D0
XU723 n566 n503 n567 n573 VDD VSS HA1D2
XU724 n312 n768 n255 VDD VSS CKAN2D0
XU725 n50 n585 n598 VDD VSS AN2XD1
XU727 value[0] FE_OFN3414_reciprocal_square_6 n504 VDD VSS CKAN2D1
XU728 value[0] n574 n506 VDD VSS CKAN2D1
XU732 n796 n460 VDD VSS INVD0
XU734 n584 n806 VDD VSS INVD0
XU741 n840 n254 VDD VSS INVD0
XU747 n1030 n940 VDD VSS INVD1
XU750 coefficient[7] n839 VDD VSS INVD1
XU752 n654 n653 n652 n201 VDD VSS OAI21D2
XU753 FE_OFN2760_reciprocal_square_0 n51 n517 VDD VSS INR2D4
XU754 n123 n234 VDD VSS CKND2
XU755 value[26] n321 n123 VDD VSS ND2D2
XU756 n982 n980 n981 n989 VDD VSS XOR3D2
XU758 n124 n1022 n47 n385 VDD VSS AOI21D4
XU759 FE_RN_16 n1001 FE_RN_18 n124 VDD VSS OAI21D4
XU760 n933 n126 VDD VSS CKND4
XU761 n931 n238 n1164 VDD VSS IND2D4
XU762 FE_OFN1353_shared_plane_22 n1045 n127 VDD VSS ND2D4
XU764 n62 n946 n134 VDD VSS ND2D4
XU766 n242 n706 n705 n711 VDD VSS XNR3D4
XU767 n887 n486 VDD VSS CKND6
XU770 n139 n176 n175 n924 VDD VSS XNR3D4
XU771 n52 n939 n457 VDD VSS ND2D4
XU772 n141 n565 VDD VSS INVD6
XU773 n144 n202 n1236 VDD VSS ND2D3
XU774 n659 n144 VDD VSS INVD2
XU776 FE_RN_2 FE_OCPN1255_n974 n292 VDD VSS NR2XD2
XU777 n40 n890 n915 VDD VSS NR2XD1
XU778 n299 n229 n150 VDD VSS INR2D2
XU779 n449 n861 n860 n863 VDD VSS XNR3D4
XU780 n1169 FE_RN_12 n889 VDD VSS CKND2D4
XU781 n929 n928 n927 n933 n934 VDD VSS FA1D4
XU782 n991 n990 n989 n935 n992 VDD VSS FA1D4
XU783 n813 n544 n812 n825 n859 VDD VSS FA1D4
XU785 n258 n685 n844 VDD VSS NR2XD3
XU787 n179 n119 n151 VDD VSS CKND2D4
XU788 n1236 n1237 n197 n1234 VDD VSS AOI21D4
XU790 n325 n1051 n577 VDD VSS NR2D2
XU791 value[4] n325 VDD VSS INVD6
XU792 n1057 n1058 n1056 n1040 n1074 VDD VSS FA1D4
XU794 FE_OFN3489_n269 n327 n561 VDD VSS INR2XD2
XU795 n285 FE_OCPN1255_n974 n291 VDD VSS ND2D4
XU797 n364 n162 n107 n961 VDD VSS XNR3D4
XU798 n221 n298 n1160 n331 VDD VSS OAI21D4
XU799 n998 n999 n1139 VDD VSS ND2D8
XU800 n1138 n206 n1139 n377 VDD VSS OAI21D4
XU801 n859 n858 n281 n866 VDD VSS XNR3D4
XU803 n179 n119 n301 n166 VDD VSS ND3D3
XU804 n954 n471 VDD VSS CKND3
XU805 n963 n964 n962 n997 n999 VDD VSS FA1D4
XU807 n998 n999 n1138 VDD VSS NR2XD4
XU808 FE_RN_1 n1132 n340 VDD VSS NR2XD4
XU810 n979 n172 n19 n988 VDD VSS XNR3D4
XU811 n214 n224 n213 n172 VDD VSS XNR3D4
XU812 n103 n673 n672 n675 VDD VSS XOR3D2
XU813 n62 n923 n176 VDD VSS ND2D4
XU814 n931 n930 n209 VDD VSS CKND2D4
XU815 n933 n932 n341 VDD VSS ND2D4
XU816 n935 n934 n298 VDD VSS NR2D8
XU817 n996 n997 n1132 VDD VSS NR2XD4
XU818 n1029 n1028 n1027 n1036 VDD VSS XOR3D2
XU819 n181 FE_RN_3 n1010 n180 VDD VSS OAI21D4
XU820 n1101 FE_RN_28 n182 n1227 VDD VSS AOI21D4
XU822 n1074 n1075 n1094 VDD VSS ND2D4
XU823 n1092 n1097 n376 VDD VSS NR2XD2
XU824 n1077 n1076 n1097 VDD VSS NR2XD4
XU825 n1075 n1074 n1092 VDD VSS NR2XD4
XU826 n428 n427 n426 n948 VDD VSS XNR3D4
XU827 n568 n187 VDD VSS INVD0
XU828 value[2] n574 n188 VDD VSS ND2D3
XU829 n673 n103 n672 n190 VDD VSS OAI21D1
XU830 n315 n1119 n1083 VDD VSS CKND2D1
XU831 n230 n1129 n191 n226 VDD VSS ND3D2
XU833 n908 n330 n907 n909 VDD VSS XOR3D2
XU834 n896 n196 VDD VSS INVD6
XU835 n659 n658 n259 VDD VSS ND2D2
XU836 n198 n657 n1240 VDD VSS ND2D4
XU837 n198 n657 n1239 VDD VSS NR2XD2
XU838 n201 n200 n199 n249 VDD VSS AOI21D4
XU839 n561 n203 FE_RN_10 n1006 VDD VSS XOR3D2
XU840 n800 n204 n516 VDD VSS INR2D2
XU841 n1052 FE_RN_25 n205 n1043 VDD VSS XOR3D2
XU842 n87 n93 n1145 VDD VSS ND2D0
XU844 n122 n946 n218 VDD VSS CKND2D8
XU845 FE_OCPN1288_n468 n208 n207 VDD VSS ND2D2
XU847 n947 n421 n393 VDD VSS IND2D2
XU848 n950 n217 VDD VSS INVD2
XU849 FE_OCPN5_shared_plane_24 FE_OFN2769_reciprocal_square_2 n395 VDD VSS
+ CKND2D4
XU850 n165 n599 n947 VDD VSS CKND2D4
XU851 n1166 n1158 FE_OCPN1158_n221 n1163 VDD VSS OAI21D0
XU852 FE_OFN2782_shared_plane_20 n940 n224 VDD VSS CKND2D4
XU853 n62 n939 n225 VDD VSS ND2D2
XU855 n1170 n888 VDD VSS INVD4
XU856 n330 n908 n264 n329 VDD VSS OAI21D2
XU857 n1184 n838 n837 n1167 VDD VSS AOI21D4
XU858 n1185 n1191 n1186 n837 VDD VSS OAI21D4
XU859 n1175 n1180 n1176 n1168 VDD VSS OAI21D4
XU861 FE_RN_38 FE_RN_39 FE_OCPN1532_n896 n246 VDD VSS IOA21D2
XU862 n234 n953 n109 n955 n1010 VDD VSS FA1D4
XU863 n1167 n889 n381 n1018 VDD VSS OAI21D4
XU864 n1168 n551 n888 n381 VDD VSS AOI21D4
XU865 n236 n441 VDD VSS INVD0
XU866 n236 FE_OCPN1576_n394 n235 VDD VSS CKND2D1
XU867 n897 n258 n900 VDD VSS INR2XD2
XU868 n392 FE_OFN2746_reciprocal_square_3 n279 VDD VSS CKND2D4
XU869 n697 n696 n244 VDD VSS ND2D2
XU871 n883 n882 n1173 VDD VSS NR2D3
XU873 n250 n374 n372 VDD VSS CKND2D2
XU874 n1035 n250 VDD VSS CKND3
XU875 n699 n252 n251 n727 VDD VSS IOA21D2
XU876 value[4] n688 VDD VSS INVD8
XU877 FE_RN_8 n758 n366 VDD VSS ND2D4
XU878 n256 n509 VDD VSS CKND2
XU879 n1236 n259 n1238 VDD VSS CKND2D1
XU881 value[15] n845 n263 VDD VSS CKND2D8
XU882 FE_OFN89_shared_plane_6 n767 n268 VDD VSS ND2D3
XU883 n688 n839 n360 VDD VSS NR2D4
XU884 n885 n884 n1176 VDD VSS ND2D4
XU885 n885 n884 n1175 VDD VSS NR2XD4
XU889 n369 n733 n125 n735 VDD VSS XNR3D4
XU892 FE_OFN89_shared_plane_6 FE_OFN2776_reciprocal_square_4 n277 VDD VSS ND2D3
XU894 n947 n949 n950 n419 VDD VSS IOA21D2
XU895 FE_OCPN1248_shared_plane_28 FE_OFN3490_n398 n1048 VDD VSS CKND2D4
XU896 n1175 n1173 n1169 VDD VSS NR2XD3
XU897 n926 n925 n924 n929 VDD VSS XOR3D2
XU898 n284 n288 VDD VSS CKND1
XU899 n284 n290 n850 n289 VDD VSS IOA21D2
XU901 n1065 n365 VDD VSS INVD1
XU902 n935 n934 n1159 VDD VSS NR2XD2
XU903 n458 n457 n456 n967 VDD VSS XNR3D4
XU904 n1149 n1154 n1150 n1134 VDD VSS OAI21D4
XU905 n1129 n299 VDD VSS INVD0
XU906 n1100 n301 VDD VSS INVD1
XU907 n1106 n303 VDD VSS INVD2
XU911 n116 n397 n772 n764 VDD VSS XNR3D4
XU912 n549 n105 n892 n905 n908 VDD VSS FA1D4
XU913 n1073 n1041 VDD VSS INVD0
XU914 n1097 n1099 VDD VSS INVD0
XU916 n38 n805 n755 VDD VSS CKND2D3
XU918 value[15] FE_OFN2757_n6 n802 VDD VSS AN2D4
XU919 value[15] n898 n869 VDD VSS CKND2D4
XU920 FE_OFN2734_shared_plane_10 FE_OFN2758_n6 n708 VDD VSS AN2XD1
XU921 n57 n806 n803 VDD VSS AN2D4
XU922 FE_OCPN3_shared_plane_12 FE_OFN2758_n6 n409 VDD VSS CKND2D4
XU923 FE_RN_9 n398 n397 VDD VSS CKND2D4
XU926 n34 FE_OFN94_n958 n699 VDD VSS NR2D3
XU928 n297 n851 n770 VDD VSS NR2D4
XU930 FE_OFN90_shared_plane_2 n734 n661 VDD VSS NR2D2
XU931 n605 n278 n592 VDD VSS NR2D1
XU932 n605 n840 n572 VDD VSS NR2XD1
XU933 n94 n481 n570 VDD VSS NR2XD1
XU934 n94 FE_OFN2756_n6 n616 VDD VSS NR2D1
XU935 n688 n1003 n601 VDD VSS NR2D3
XU937 n335 n334 n333 n332 n910 VDD VSS OAI22D4
XU938 n906 n332 VDD VSS INVD1
XU939 n906 n905 n904 n912 VDD VSS XOR3D2
XU940 n898 n336 n539 VDD VSS INR2XD2
XU941 n684 n683 n682 n693 VDD VSS XOR3D2
XU942 n346 n612 n651 VDD VSS CKXOR2D1
XU943 n257 n573 n572 n587 VDD VSS XOR3D2
XU944 n572 n348 n347 n671 VDD VSS IOA21D2
XU945 n38 n806 n769 VDD VSS AN2D4
XU946 n354 n353 n352 VDD VSS ND2D3
XU948 n752 n751 n356 VDD VSS ND2D4
XU949 n774 n773 n362 n786 VDD VSS XOR3D2
XU950 FE_OCPN1280_n774 n362 n361 n783 VDD VSS IOA21D2
XU951 n733 n369 n514 n368 VDD VSS OAI21D1
XU952 n313 n575 n369 VDD VSS NR2XD2
XU954 n372 n1034 n371 VDD VSS ND2D2
XU955 n803 n380 n379 VDD VSS IND2D2
XU956 n804 n803 n535 n811 VDD VSS XOR3D2
XU957 n325 FE_OFN2755_n6 n622 VDD VSS NR2D2
XU958 n1200 n1199 scaled_value[8] VDD VSS CKXOR2D1
XU959 n985 n984 n983 n986 VDD VSS XOR3D2
XU960 n898 n311 n528 VDD VSS INR2XD2
XU961 n738 n737 n739 n746 VDD VSS XOR3D2
XU962 n745 n382 n743 n750 VDD VSS XNR3D4
XU964 n565 n386 VDD VSS CKND8
XU965 n868 n867 n866 n836 n882 VDD VSS FA1D4
XU966 n45 n960 n391 VDD VSS NR2XD2
XU967 n1044 n1043 n1042 n1058 n1061 VDD VSS FA1D4
XU968 n842 n311 n526 VDD VSS INR2D4
XU969 n295 n851 n852 VDD VSS NR2XD2
XU971 n65 FE_OFN2796_reciprocal_square_5 n522 VDD VSS NR2D3
XU972 n836 n835 n1186 VDD VSS ND2D2
XU973 n832 n831 n830 n792 n833 VDD VSS FA1D4
XU974 n792 n791 n793 VDD VSS NR2D8
XU975 n418 n120 n417 VDD VSS CKXOR2D1
XU976 n419 n393 n418 VDD VSS ND2D3
XU977 FE_RN_38 n422 VDD VSS CKND1
XU978 n1221 n1116 VDD VSS CKND2
XU979 n295 n796 n846 VDD VSS NR2D3
XU981 n484 n872 n871 n879 VDD VSS XNR3D4
XU982 n397 n771 VDD VSS INVD1
XU983 n792 n791 n1197 VDD VSS ND2D3
XU984 FE_OCPN1405_n822 n823 n406 n828 VDD VSS IOA21D2
XU985 n408 n407 FE_OCPN1534_n821 n406 VDD VSS IOA21D2
XU986 n408 n822 n821 n830 VDD VSS XNR3D4
XU987 FE_OCPN1293_n468 n467 VDD VSS CKND2
XU988 n472 n969 n412 n974 VDD VSS IOA21D2
XU989 n969 n472 n414 VDD VSS NR2D3
XU991 n417 n965 n977 VDD VSS XNR2D4
XU992 n887 n886 n1170 VDD VSS ND2D4
XU993 n437 n474 n864 VDD VSS ND2D2
XU994 n440 n816 n760 n809 VDD VSS XNR3D4
XU995 FE_OFN86_shared_plane_13 FE_OFN2747_reciprocal_square_3 n440 VDD VSS
+ ND2D3
XU998 n445 n736 n735 n745 VDD VSS XNR3D4
XU999 n861 n862 n447 n880 VDD VSS IOA21D2
XU1001 n324 n839 n719 VDD VSS NR2D4
XU1002 n750 n749 n1209 VDD VSS NR2XD2
XU1003 n86 n796 n718 VDD VSS NR2D3
XU1004 n457 n458 n455 VDD VSS ND2D2
XU1005 FE_OFN2782_shared_plane_20 n923 n456 VDD VSS ND2D2
XU1006 n744 n745 n461 VDD VSS ND2D1
XU1007 n466 n467 n465 n956 VDD VSS IOA21D2
XU1008 n471 n470 n469 n1013 VDD VSS OAI21D4
XU1013 n499 n498 n497 n976 VDD VSS OAI21D4
XU1014 n1121 n1120 n500 VDD VSS OR2XD1
XU1015 FE_OFN2782_shared_plane_20 n800 n508 VDD VSS AN2D4
XU1016 FE_OFN2782_shared_plane_20 FE_OFN2760_reciprocal_square_0 n510 VDD VSS
+ AN2D4
XU1017 FE_OFN3413_shared_plane_7 n806 n521 VDD VSS AN2D4
XU1019 n370 n891 n532 VDD VSS AN2XD1
XU1020 n67 FE_OFN2797_reciprocal_square_5 n535 VDD VSS AN2D2
XU1021 n68 n958 n536 VDD VSS AN2D4
XU1022 n67 n399 n537 VDD VSS AN2D4
XU1023 FE_OFN85_shared_plane_16 n842 n542 VDD VSS AN2D4
XU1024 FE_OFN2767_shared_plane_16 n845 n546 VDD VSS AN2D4
XU1027 n36 n668 n552 VDD VSS AN2D1
XU1028 n314 FE_OFN3414_reciprocal_square_6 n556 VDD VSS AN2D2
XU1029 n36 FE_OFN2775_reciprocal_square_4 n557 VDD VSS CKAN2D1
XU1030 n36 FE_OFN2746_reciprocal_square_3 n558 VDD VSS CKAN2D1
XU1031 n1125 n1126 n1221 VDD VSS NR2D2
XU1032 FE_OFN3494_n942 n945 VDD VSS INVD6
XU1033 n297 n701 n581 VDD VSS NR2D3
XU1034 FE_OCPN1406_n1197 FE_OCPN1539_n1198 n1199 VDD VSS CKND2D0
XU1038 n325 n798 n588 VDD VSS NR2D2
XU1039 n839 n734 VDD VSS BUFFD1
XU1040 n734 n851 VDD VSS BUFFD2
XU1041 n851 n668 VDD VSS INVD2
XU1043 n324 n757 n596 VDD VSS NR2XD2
XU1044 n720 FE_OFN2755_n6 n595 VDD VSS NR2XD1
XU1045 n720 n1003 n569 VDD VSS NR2D2
XU1046 n94 n798 n670 VDD VSS NR2D2
XU1047 n720 FE_OFN94_n958 n669 VDD VSS NR2D2
XU1048 FE_OFN90_shared_plane_2 n759 n602 VDD VSS NR2XD0
XU1049 n370 n679 n665 VDD VSS AN2D1
XU1050 n688 n808 n660 VDD VSS NR2D2
XU1051 FE_OCPN1506_n86 n701 n615 VDD VSS NR2XD1
XU1052 n102 n507 n627 n604 VDD VSS HA1D0
XU1053 FE_OFN90_shared_plane_2 n757 n626 VDD VSS NR2D1
XU1054 n604 n603 n602 n620 n600 VDD VSS FA1D1
XU1055 n94 n716 n619 VDD VSS NR2XD0
XU1056 n325 n938 n624 VDD VSS NR2D2
XU1057 n598 n501 n630 n628 VDD VSS HA1D1
XU1058 n605 FE_OFN2756_n6 n629 VDD VSS NR2D1
XU1059 n651 n650 n654 VDD VSS NR2XD1
XU1060 n628 n627 n626 n642 n621 VDD VSS FA1D0
XU1061 n643 n642 n645 VDD VSS NR2D1
XU1062 n631 n630 n629 n638 n623 VDD VSS FA1D1
XU1064 n638 n553 n641 VDD VSS NR2D0
XU1065 n195 n505 n635 n631 VDD VSS HA1D1
XU1066 n633 FE_OFN2756_n6 n634 VDD VSS NR2D0
XU1067 n255 n634 n637 VDD VSS AN2XD1
XU1068 n512 n635 n636 VDD VSS CKAN2D0
XU1069 n638 n553 n639 VDD VSS CKND2D0
XU1070 n643 n642 n644 VDD VSS CKND2D0
XU1071 n645 n502 n644 n649 VDD VSS OAI21D1
XU1072 n647 n646 n648 VDD VSS AN2XD1
XU1073 n554 n649 n648 n653 VDD VSS AOI21D1
XU1074 n651 n650 n652 VDD VSS ND2D2
XU1075 n370 n316 n691 VDD VSS AN2XD1
XU1076 n324 n808 n686 VDD VSS NR2D4
XU1078 n295 n701 n726 VDD VSS NR2D2
XU1079 n68 n121 n722 VDD VSS AN2XD1
XU1080 n715 n714 n1214 VDD VSS NR2D8
XU1081 n1217 n1214 n1215 n1204 VDD VSS OAI21D4
XU1084 n720 n851 n724 VDD VSS NR2D4
XU1085 n34 FE_OFN2796_reciprocal_square_5 n723 VDD VSS NR2D8
XU1086 n531 n515 n722 n737 n742 VDD VSS FA1D2
XU1088 n755 n804 VDD VSS CKND2
XU1090 n35 FE_OFN2774_reciprocal_square_4 n816 VDD VSS NR2D2
XU1092 n793 n1198 VDD VSS CKND4
XU1093 n790 n789 n1201 VDD VSS CKND2D4
XU1094 FE_OFN2796_reciprocal_square_5 n1030 VDD VSS CKBD1
XU1095 n1030 n870 VDD VSS INVD0
XU1098 n799 n817 VDD VSS CKND2
XU1099 n67 n806 n807 VDD VSS CKND2D2
XU1100 n807 n815 VDD VSS CKND2
XU1101 n35 FE_OFN2796_reciprocal_square_5 n814 VDD VSS NR2XD1
XU1103 n1065 n897 VDD VSS CKND2
XU1104 n1046 n898 VDD VSS INVD2
XU1105 n869 n893 VDD VSS CKND4
XU1106 n363 n121 n899 VDD VSS AN2D4
XU1107 n516 n550 n874 n872 n906 VDD VSS FA1D4
XU1108 n1046 n939 VDD VSS INVD1
XU1109 n911 n910 n909 n931 n932 VDD VSS FA1D4
XU1113 n956 n955 n954 n962 VDD VSS XOR3D2
XU1114 n976 n977 n975 n995 n996 VDD VSS FA1D4
XU1115 n1005 n1006 n1004 n1012 n1037 VDD VSS FA1D1
XU1116 n1008 n1009 n1007 n1005 n1029 VDD VSS FA1D4
XU1117 n1022 n294 n1017 VDD VSS CKND2D3
XU1118 n1018 n1166 VDD VSS CKND2
XU1119 n1021 n1020 scaled_value[15] VDD VSS XNR2D2
XU1120 n1050 n1064 VDD VSS INVD1
XU1121 n1061 n1060 n1059 n1075 n1077 VDD VSS FA1D4
XU1122 n1068 n1069 n1067 n1060 n1080 VDD VSS FA1D4
XU1123 n1083 n1112 VDD VSS INVD1
XU1124 n1084 n1111 VDD VSS INVD1
XU1125 n1125 n1090 VDD VSS INVD1
XU1126 n1103 n1105 VDD VSS CKND4
XU1128 n1225 n1115 VDD VSS INVD1
XU1130 n1130 n1157 VDD VSS INVD2
XU1131 n1131 n1133 VDD VSS INVD1
XU1132 n1133 n1144 n1137 VDD VSS NR2XD0
XU1135 n1140 FE_OCPN1139_n1139 n1141 VDD VSS CKND2D1
XU1136 n1157 n1131 n1135 n1146 VDD VSS AOI21D1
XU1137 n1147 n1155 VDD VSS INVD0
XU1138 FE_OCPN1519_n1154 n1148 VDD VSS INVD1
XU1139 n1157 n1155 n1148 n1153 VDD VSS AOI21D1
XU1141 n1155 FE_OCPN1519_n1154 n1156 VDD VSS CKND2D0
XU1142 n298 n1161 VDD VSS INVD0
XU1143 n1167 n1183 VDD VSS INVD1
XU1144 n1183 FE_PSN1625_n1169 FE_OCPN1142_n1168 n1172 VDD VSS AOI21D1
XU1145 FE_OCPN1501_n1173 n1181 VDD VSS INVD1
XU1146 FE_OCPN1162_n1180 n1174 VDD VSS INVD1
XU1147 n1183 n1181 n1174 n1179 VDD VSS AOI21D4
XU1148 n1181 FE_OCPN1162_n1180 n1182 VDD VSS CKND2D1
XU1149 FE_OCPN1235_n1184 n1194 VDD VSS CKND2
XU1150 n1194 n1190 FE_OCPN1596_n1191 n1189 VDD VSS OAI21D1
XU1151 FE_OCPN1249_n1185 n1187 VDD VSS INVD1
XU1152 n1187 FE_OCPN1404_n1186 n1188 VDD VSS CKND2D1
XU1153 n1195 n1203 VDD VSS INVD1
XU1154 FE_OCPN1500_n1201 n1196 VDD VSS INVD1
XU1155 n1203 n115 n1196 n1200 VDD VSS AOI21D1
XU1156 n115 FE_OCPN1500_n1201 n1202 VDD VSS CKND2D1
XU1157 FE_OCPN1253_n1204 n1212 VDD VSS INVD1
XU1158 n1212 FE_OCPN1482_n1209 FE_OCPN1558_n1210 n1208 VDD VSS OAI21D1
XU1159 FE_OCPN1482_n1209 n1211 VDD VSS INVD1
XU1160 n1211 n1210 n1213 VDD VSS CKND2D1
XU1162 n1218 n1217 scaled_value[4] VDD VSS XOR2D0
XU1163 n1222 n1228 n1230 VDD VSS NR2D0
XU1164 n1231 n1233 VDD VSS INVD0
XU1165 n1239 n1241 VDD VSS INVD0
.ENDS

.SUBCKT oadm_core x_mantissa[23] x_mantissa[22] x_mantissa[21] x_mantissa[20]
+ x_mantissa[19] x_mantissa[18] x_mantissa[17] x_mantissa[16] x_mantissa[15]
+ x_mantissa[14] x_mantissa[13] x_mantissa[12] x_mantissa[11] x_mantissa[10]
+ x_mantissa[9] x_mantissa[8] x_mantissa[7] x_mantissa[6] x_mantissa[5]
+ x_mantissa[4] x_mantissa[3] x_mantissa[2] x_mantissa[1] x_mantissa[0]
+ y_mantissa[23] y_mantissa[22] y_mantissa[21] y_mantissa[20] y_mantissa[19]
+ y_mantissa[18] y_mantissa[17] y_mantissa[16] y_mantissa[15] y_mantissa[14]
+ y_mantissa[13] y_mantissa[12] y_mantissa[11] y_mantissa[10] y_mantissa[9]
+ y_mantissa[8] y_mantissa[7] y_mantissa[6] y_mantissa[5] y_mantissa[4]
+ y_mantissa[3] y_mantissa[2] y_mantissa[1] y_mantissa[0] level[1] level[0]
+ divide_mode mantissa_value[28] mantissa_value[27] mantissa_value[26]
+ mantissa_value[25] mantissa_value[24] mantissa_value[23] mantissa_value[22]
+ mantissa_value[21] mantissa_value[20] mantissa_value[19] mantissa_value[18]
+ mantissa_value[17] mantissa_value[16] mantissa_value[15] mantissa_value[14]
+ mantissa_value[13] mantissa_value[12] mantissa_value[11] mantissa_value[10]
+ mantissa_value[9] mantissa_value[8] mantissa_value[7] mantissa_value[6]
+ mantissa_value[5] mantissa_value[4] mantissa_value[3] mantissa_value[2]
+ mantissa_value[1] mantissa_value[0] VDD VSS FE_OFN0_y_1 FE_OCPN1_y_4
+ FE_OCPN2_x_3 FE_OCPN8_y_0 FE_OCPN9_x_4 FE_OCPN11_y_2 FE_OCPN10_y_2
+ FE_OCPN12_n239 FE_OCPN13_FE_OFN21_x_6
XFE_PSC1654_n1924 n1924 FE_PSN1654_n1924 VDD VSS CKBD1
XFE_PSC1653_n2353 n2353 FE_PSN1653_n2353 VDD VSS BUFFD4
XFE_PSC1651_n304 x_mantissa[1] FE_PSN1651_n304 VDD VSS CKBD12
XFE_PSC1650_n3355 n3355 FE_PSN1650_n3355 VDD VSS CKBD0
XFE_PSC1649_FE_OFN2749_shared_plane_6 FE_OFN2749_shared_plane_6
+ FE_PSN1649_FE_OFN2749_shared_plane_6 VDD VSS CKBD0
XFE_PSC1647_csa_carry_1_15 csa_carry_1[15] FE_PSN1647_csa_carry_1_15 VDD VSS
+ CKBD1
XFE_PSC1644_n3331 n3331 FE_PSN1644_n3331 VDD VSS BUFFD2
XFE_PSC1641_n2517 n2517 FE_PSN1641_n2517 VDD VSS CKBD1
XFE_PSC1638_n2844 n2844 FE_PSN1638_n2844 VDD VSS BUFFD4
XFE_PSC1636_n566 n566 FE_PSN1636_n566 VDD VSS BUFFD2
XFE_PSC1635_n702 n702 FE_PSN1635_n702 VDD VSS BUFFD2
XFE_PSC1634_n2840 n2840 FE_PSN1634_n2840 VDD VSS BUFFD2
XFE_PSC1632_n178 n178 FE_PSN1632_n178 VDD VSS BUFFD2
XFE_PSC1628_n2352 n2352 FE_PSN1628_n2352 VDD VSS BUFFD2
XFE_PSC1626_n1507 n1507 FE_PSN1626_n1507 VDD VSS BUFFD4
XFE_PSC1624_n1794 n1794 FE_PSN1624_n1794 VDD VSS CKBD1
XFE_PSC1619_n1021 n1021 FE_PSN1619_n1021 VDD VSS BUFFD2
XFE_PSC1617_FE_OFN1126_x_0 x_mantissa[0] FE_PSN1617_FE_OFN1126_x_0 VDD VSS
+ BUFFD8
XFE_OCPC1612_n1255 n1255 FE_OCPN1612_n1255 VDD VSS CKBD0
XFE_OCPC1609_FE_OFN2770_shared_plane_13 FE_OFN2770_shared_plane_13
+ FE_OCPN1609_FE_OFN2770_shared_plane_13 VDD VSS CKBD0
XFE_OCPC1608_n3394 n3394 FE_OCPN1608_n3394 VDD VSS CKBD0
XFE_OCPC1607_n2339 n2339 FE_OCPN1607_n2339 VDD VSS BUFFD4
XFE_OCPC1605_n3345 n3345 FE_OCPN1605_n3345 VDD VSS BUFFD2
XFE_OCPC1604_n541 n541 FE_OCPN1604_n541 VDD VSS CKBD4
XFE_OCPC1603_n287 n287 FE_OCPN1603_n287 VDD VSS CKBD1
XFE_OCPC1601_n1363 n1363 FE_OCPN1601_n1363 VDD VSS BUFFD4
XFE_OCPC1600_n3275 n3275 FE_OCPN1600_n3275 VDD VSS CKBD1
XFE_OCPC1598_n2467 n2467 FE_OCPN1598_n2467 VDD VSS CKBD4
XFE_OCPC1597_n3510 n3510 FE_OCPN1597_n3510 VDD VSS BUFFD2
XFE_OCPC1595_n3393 n3393 FE_OCPN1595_n3393 VDD VSS CKBD0
XFE_OCPC1592_n1690 n1690 FE_OCPN1592_n1690 VDD VSS CKBD4
XFE_OCPC1591_n2986 n2986 FE_OCPN1591_n2986 VDD VSS CKBD0
XFE_OCPC1590_n2366 n2366 FE_OCPN1590_n2366 VDD VSS BUFFD4
XFE_OCPC1589_FE_RN_117 FE_RN_117 FE_OCPN1589_FE_RN_117 VDD VSS BUFFD2
XFE_OCPC1588_n3540 n3540 FE_OCPN1588_n3540 VDD VSS BUFFD2
XFE_OCPC1587_n3228 n3228 FE_OCPN1587_n3228 VDD VSS CKBD1
XFE_OCPC1586_n2686 FE_OCPN1492_n2686 FE_OCPN1586_n2686 VDD VSS CKBD0
XFE_OCPC1584_n1813 n1813 FE_OCPN1584_n1813 VDD VSS BUFFD2
XFE_OCPC1583_n92 n92 FE_OCPN1583_n92 VDD VSS CKBD0
XFE_OCPC1582_n2901 n2901 FE_OCPN1582_n2901 VDD VSS CKBD1
XU1120_dup n684 n683 FE_RN_101 VDD VSS CKND2D8
XFE_OCPC1580_n3622 n3622 FE_OCPN1580_n3622 VDD VSS BUFFD4
XFE_OCPC1578_n2768 n2768 FE_OCPN1578_n2768 VDD VSS BUFFD4
XFE_OCPC1573_n3548 n3548 FE_OCPN1573_n3548 VDD VSS BUFFD1
XFE_RC_1752_0 n957 FE_OCPN1604_n541 FE_RN_88_0 VDD VSS CKND2D4
XFE_RC_1751_0 n541 FE_RN_972_0 VDD VSS INVD1
XFE_RC_1750_0 FE_RN_972_0 n957 FE_RN_973_0 VDD VSS IND2D4
XFE_RC_1749_0 FE_RN_973_0 FE_RN_87_0 n1340 FE_RN_950_0 VDD VSS AOI21D4
XFE_OCPC1571_FE_OFN112_n2457 FE_OFN112_n2457 FE_OCPN1571_FE_OFN112_n2457 VDD
+ VSS BUFFD4
XFE_OCPC1570_n21 n21 FE_OCPN1570_n21 VDD VSS BUFFD2
XFE_OCPC1569_n1066 n1066 FE_OCPN1569_n1066 VDD VSS BUFFD2
XFE_OCPC1568_n2349 n2349 FE_OCPN1568_n2349 VDD VSS CKBD0
XFE_OCPC1567_n2195 n2195 FE_OCPN1567_n2195 VDD VSS CKBD1
XFE_OCPC1566_n2677 n2677 FE_OCPN1566_n2677 VDD VSS CKBD4
XFE_OCPC1565_n3384 n3384 FE_OCPN1565_n3384 VDD VSS BUFFD4
XFE_OCPC1560_n395 n395 FE_OCPN1560_n395 VDD VSS CKBD1
XFE_OCPC1559_n2009 n2009 FE_OCPN1559_n2009 VDD VSS CKBD1
XU789_dup n104 FE_OCPN1603_n287 FE_RN_75 VDD VSS CKND2D4
XFE_OCPC1557_n2966 n2966 FE_OCPN1557_n2966 VDD VSS BUFFD2
XFE_OCPC1556_n3554 n3554 FE_OCPN1556_n3554 VDD VSS CKBD0
XFE_OCPC1555_n3629 n3629 FE_OCPN1555_n3629 VDD VSS BUFFD4
XFE_OCPC1553_n2980 FE_OCPN3444_n2980 FE_OCPN1553_n2980 VDD VSS BUFFD2
XFE_OCPC1551_n3733 n3733 FE_OCPN1551_n3733 VDD VSS CKBD1
XFE_OCPC1550_n1802 n1802 FE_OCPN1550_n1802 VDD VSS BUFFD2
XFE_OCPC1549_n1650 n1650 FE_OCPN1549_n1650 VDD VSS CKBD1
XFE_OCPC1548_n2793 n2793 FE_OCPN1548_n2793 VDD VSS BUFFD2
XFE_OCPC1546_n1964 n1964 FE_OCPN1546_n1964 VDD VSS CKBD1
XFE_OCPC1545_n402 n402 FE_OCPN1545_n402 VDD VSS BUFFD4
XFE_OCPC1544_n2261 n2261 FE_OCPN1544_n2261 VDD VSS CKBD0
XFE_OCPC1543_n701 n701 FE_OCPN1543_n701 VDD VSS BUFFD4
XFE_OCPC1542_n3642 n3642 FE_OCPN1542_n3642 VDD VSS CKBD4
XFE_OCPC1541_n1617 n1617 FE_OCPN1541_n1617 VDD VSS BUFFD2
XFE_OCPC1540_n2475 n2475 FE_OCPN1540_n2475 VDD VSS CKBD1
XFE_OCPC1537_n1339 n1339 FE_OCPN1537_n1339 VDD VSS CKBD4
XFE_OCPC1536_n3240 n3240 FE_OCPN1536_n3240 VDD VSS CKBD0
XFE_OCPC1529_n2781 n2781 FE_OCPN1529_n2781 VDD VSS CKBD1
XFE_OCPC1527_n1053 n1053 FE_OCPN1527_n1053 VDD VSS BUFFD4
XFE_OCPC1526_n1748 n1748 FE_OCPN1526_n1748 VDD VSS CKBD4
XFE_OCPC1525_n1616 n1616 FE_OCPN1525_n1616 VDD VSS CKBD0
XFE_OCPC1520_n3599 n3599 FE_OCPN1520_n3599 VDD VSS CKBD1
XFE_OCPC1515_n2840 n2840 FE_OCPN1515_n2840 VDD VSS BUFFD4
XFE_OCPC1514_n877 n877 FE_OCPN1514_n877 VDD VSS BUFFD4
XFE_OCPC1513_n3475 n3475 FE_OCPN1513_n3475 VDD VSS CKBD1
XFE_OCPC1510_n3729 n3729 FE_OCPN1510_n3729 VDD VSS CKBD1
XFE_OCPC1509_n1364 n1364 FE_OCPN1509_n1364 VDD VSS BUFFD4
XFE_OCPC1508_n592 n592 FE_OCPN1508_n592 VDD VSS CKBD4
XFE_OCPC1507_shared_plane_20 shared_plane[20] FE_OCPN1507_shared_plane_20 VDD
+ VSS CKBD0
XFE_OCPC1505_FE_OFN112_n2457 FE_OCPN1571_FE_OFN112_n2457
+ FE_OCPN1505_FE_OFN112_n2457 VDD VSS CKBD1
XFE_OCPC1504_n3523 n3523 FE_OCPN1504_n3523 VDD VSS CKBD0
XFE_OCPC1503_n3384 n3384 FE_OCPN1503_n3384 VDD VSS CKBD1
XU2504_dup n1880 n1881 FE_RN_61 VDD VSS CKND2D4
XFE_OCPC1496_n1760 n1760 FE_OCPN1496_n1760 VDD VSS CKBD4
XFE_OCPC1495_n1916 n1916 FE_OCPN1495_n1916 VDD VSS BUFFD4
XFE_OCPC1493_n3670 n3670 FE_OCPN1493_n3670 VDD VSS CKBD1
XFE_OCPC1492_n2686 n2686 FE_OCPN1492_n2686 VDD VSS BUFFD4
XFE_OCPC1491_n3519 n3519 FE_OCPN1491_n3519 VDD VSS CKBD1
XFE_OCPC1490_n1914 n1914 FE_OCPN1490_n1914 VDD VSS BUFFD4
XFE_OCPC1489_FE_RN_12 FE_RN_12 FE_OCPN1489_FE_RN_12 VDD VSS CKBD1
XFE_OCPC1488_n1927 n1927 FE_OCPN1488_n1927 VDD VSS BUFFD2
XFE_OCPC1487_n2278 n2278 FE_OCPN1487_n2278 VDD VSS CKBD1
XFE_OCPC1485_n3219 n3219 FE_OCPN1485_n3219 VDD VSS CKBD0
XFE_OCPC1484_n1964 n1964 FE_OCPN1484_n1964 VDD VSS BUFFD2
XFE_OCPC1483_n2049 n2049 FE_OCPN1483_n2049 VDD VSS CKBD1
XFE_OCPC1481_FE_OFN10_x_21 x_mantissa[21] FE_OCPN1481_FE_OFN10_x_21 VDD VSS
+ CKBD1
XFE_OCPC1480_n2735 n2735 FE_OCPN1480_n2735 VDD VSS BUFFD2
XFE_OCPC1479_FE_RN_4 FE_RN_4 FE_OCPN1479_FE_RN_4 VDD VSS BUFFD4
XFE_OCPC1478_FE_OFN51_y_6 y_mantissa[6] FE_OCPN1478_FE_OFN51_y_6 VDD VSS CKBD4
XFE_OCPC1477_n308 x_mantissa[9] FE_OCPN1477_n308 VDD VSS CKBD4
XFE_OCPC1476_FE_OFN1126_x_0 x_mantissa[0] FE_OCPN1476_FE_OFN1126_x_0 VDD VSS
+ BUFFD4
XFE_OCPC1475_n2349 n2349 FE_OCPN1475_n2349 VDD VSS CKBD1
XFE_OCPC1473_n2760 n2760 FE_OCPN1473_n2760 VDD VSS CKBD2
XFE_OCPC1472_n2731 n2731 FE_OCPN1472_n2731 VDD VSS CKBD1
XFE_OCPC1470_n1794 n1794 FE_OCPN1470_n1794 VDD VSS CKBD1
XFE_OCPC1469_n2792 n2792 FE_OCPN1469_n2792 VDD VSS CKBD1
XFE_OCPC1467_n1677 n1677 FE_OCPN1467_n1677 VDD VSS CKBD4
XFE_OCPC1466_n3355 n3355 FE_OCPN1466_n3355 VDD VSS CKBD1
XFE_OCPC1465_n430 n430 FE_OCPN1465_n430 VDD VSS CKBD4
XFE_OCPC1464_n2628 n2628 FE_OCPN1464_n2628 VDD VSS BUFFD2
XFE_OCPC1463_n3318 n3318 FE_OCPN1463_n3318 VDD VSS CKBD4
XFE_OCPC1462_n3347 n3347 FE_OCPN1462_n3347 VDD VSS CKBD1
XFE_OCPC1461_n113 n113 FE_OCPN1461_n113 VDD VSS CKBD4
XFE_OCPC1460_n2094 n2094 FE_OCPN1460_n2094 VDD VSS BUFFD4
XFE_OCPC1459_FE_OFN23_x_4 x_mantissa[4] FE_OCPN1459_FE_OFN23_x_4 VDD VSS BUFFD4
XFE_OCPC1457_FE_OFN2722_y_1 y_mantissa[1] FE_OCPN1457_FE_OFN2722_y_1 VDD VSS
+ BUFFD4
XFE_OCPC1456_FE_RN_25 FE_RN_25 FE_OCPN1456_FE_RN_25 VDD VSS BUFFD4
XFE_RC_1738_0 n2085 n596 FE_RN_414_0 FE_RN_77_0 VDD VSS ND3D3
XFE_OCPC1453_n2561 n2561 FE_OCPN1453_n2561 VDD VSS BUFFD4
XFE_RC_1737_0 n1129 n2683 FE_RN_953_0 VDD VSS ND2D2
XFE_RC_1736_0 n1129 n2683 FE_RN_953_0 FE_RN_954_0 VDD VSS OAI21D2
XFE_RC_1735_0 FE_RN_954_0 n111 FE_RN_955_0 VDD VSS ND2D4
XFE_RC_1734_0 n2683 FE_RN_956_0 VDD VSS CKND2
XFE_RC_1733_0 n2681 FE_RN_957_0 VDD VSS CKND1
XFE_RC_1732_0 n3744 n2682 FE_RN_958_0 VDD VSS CKND2D2
XFE_RC_1731_0 FE_RN_958_0 FE_RN_957_0 FE_RN_959_0 VDD VSS ND2D2
XFE_RC_1730_0 FE_RN_959_0 FE_RN_956_0 FE_RN_960_0 VDD VSS NR2XD2
XFE_RC_1729_0 n2682 FE_RN_961_0 VDD VSS CKND1
XFE_RC_1728_0 FE_RN_961_0 FE_RN_125 FE_RN_962_0 VDD VSS IND2D4
XFE_RC_1727_0 FE_RN_962_0 FE_RN_781_0 n2683 FE_RN_963_0 VDD VSS AOI21D4
XFE_RC_1726_0 FE_RN_963_0 FE_RN_960_0 n3747 FE_RN_964_0 VDD VSS OAI21D4
XFE_RC_1725_0 FE_RN_964_0 FE_RN_955_0 base_plane[7] VDD VSS CKND2D8
XFE_RC_1724_0 n2737 FE_RN_949_0 VDD VSS CKND3
XFE_RC_1722_0 FE_RN_88_0 FE_RN_87_0 FE_RN_951_0 VDD VSS ND2D2
XFE_RC_1721_0 n1340 FE_RN_951_0 FE_RN_952_0 VDD VSS INR2D4
XFE_RC_1720_0 FE_RN_952_0 FE_RN_950_0 FE_RN_949_0 n3869 VDD VSS NR3D3
XFE_OCPC1449_n669 n669 FE_OCPN1449_n669 VDD VSS BUFFD4
XFE_RC_1719_0 n3603 FE_RN_944_0 VDD VSS CKND2
XFE_RC_1718_0 n3602 FE_RN_945_0 VDD VSS INVD2
XFE_RC_1717_0 n1755 FE_RN_945_0 FE_RN_946_0 VDD VSS OR2D4
XFE_RC_1716_0 n3602 FE_RN_947_0 VDD VSS CKND2
XFE_RC_1715_0 n1755 FE_RN_947_0 FE_RN_948_0 VDD VSS CKND2D4
XFE_RC_1714_0 FE_RN_948_0 FE_RN_946_0 FE_RN_944_0 n3857 VDD VSS AOI21D4
XFE_OCPC1448_n3128 FE_OCPN3519_n3128 FE_OCPN1448_n3128 VDD VSS CKBD2
XFE_OCPC1446_FE_RN_45 FE_RN_45 FE_OCPN1446_FE_RN_45 VDD VSS BUFFD4
XFE_OCPC1445_n62 n62 FE_OCPN1445_n62 VDD VSS BUFFD4
XFE_OCPC1444_n2475 n2475 FE_OCPN1444_n2475 VDD VSS CKBD4
XFE_OCPC1442_FE_RN_812_0 FE_RN_812_0 FE_OCPN1442_FE_RN_812_0 VDD VSS CKBD0
XFE_OCPC1441_n1069 n1069 FE_OCPN1441_n1069 VDD VSS CKBD4
XFE_OCPC1440_FE_RN_44 FE_RN_44 FE_OCPN1440_FE_RN_44 VDD VSS BUFFD2
XFE_OCPC1438_n2342 n2342 FE_OCPN1438_n2342 VDD VSS BUFFD4
XFE_OCPC1437_n1066 n1066 FE_OCPN1437_n1066 VDD VSS CKBD1
XFE_OCPC1434_n2092 n2092 FE_OCPN1434_n2092 VDD VSS BUFFD4
XFE_OCPC1433_n3128 n3128 FE_OCPN1433_n3128 VDD VSS BUFFD4
XFE_OCPC1432_n883 n883 FE_OCPN1432_n883 VDD VSS BUFFD4
XFE_OCPC1431_n766 n766 FE_OCPN1431_n766 VDD VSS BUFFD4
XFE_OCPC1430_n1298 n1298 FE_OCPN1430_n1298 VDD VSS BUFFD2
XFE_RC_1710_0 n3634 n878 FE_RN_939_0 FE_RN_938_0 VDD VSS IND3D2
XFE_RC_1709_0 FE_OCPN1555_n3629 n943 n946 FE_RN_939_0 VDD VSS ND3D4
XFE_RC_1708_0 FE_RN_939_0 n878 FE_RN_940_0 VDD VSS ND2D2
XFE_RC_1707_0 FE_RN_940_0 n3634 FE_RN_941_0 VDD VSS CKND2D2
XFE_RC_1706_0 FE_RN_941_0 FE_RN_938_0 n1334 VDD VSS ND2D3
XFE_OCPC1429_n1148 n1148 FE_OCPN1429_n1148 VDD VSS BUFFD4
XFE_OCPC1428_n2740 n2740 FE_OCPN1428_n2740 VDD VSS CKBD4
XFE_OCPC1424_n1137 n1137 FE_OCPN1424_n1137 VDD VSS CKBD1
XU349_dup n549 n1067 FE_RN_74 VDD VSS AN2D4
XFE_OCPC1423_n1150 n1150 FE_OCPN1423_n1150 VDD VSS BUFFD4
XFE_OCPC1421_n1941 n1941 FE_OCPN1421_n1941 VDD VSS BUFFD2
XFE_OCPC1420_n428 n428 FE_OCPN1420_n428 VDD VSS CKBD1
XFE_RC_1702_0 FE_OCPN1275_n872 FE_RN_45 FE_RN_935_0 VDD VSS IND2D4
XFE_RC_1701_0 FE_OCPN1275_n872 FE_RN_936_0 VDD VSS INVD4
XFE_RC_1700_0 FE_RN_45 FE_RN_936_0 FE_RN_935_0 FE_RN_54 VDD VSS OAI21D4
XFE_RC_1699_0 FE_RN_501_0 FE_RN_933_0 VDD VSS CKND1
XFE_RC_1698_0 FE_RN_87 FE_RN_136 FE_RN_934_0 VDD VSS ND2D2
XFE_RC_1697_0 FE_RN_934_0 FE_RN_933_0 n379 VDD VSS ND2D2
XFE_OCPC1414_n3329 n3329 FE_OCPN1414_n3329 VDD VSS BUFFD2
XU3283_dup n1460 n2657 FE_RN_22 VDD VSS CKND2D4
XFE_RC_1696_0 n3015 n1582 FE_RN_932_0 VDD VSS ND2D3
XFE_RC_1695_0 FE_RN_932_0 n773 n2171 VDD VSS ND2D8
XFE_RC_1694_0 n1493 n1492 n2067 VDD VSS CKND2D4
XFE_RC_1693_0 n1492 n1493 n2935 VDD VSS AN2D4
XFE_RC_1691_0 n3043 FE_RN_930_0 VDD VSS INVD1
XFE_RC_1690_0 FE_RN_930_0 n1305 FE_RN_931_0 VDD VSS IND2D4
XFE_RC_1689_0 n3042 FE_RN_112_0 FE_RN_931_0 FE_RN_113_0 VDD VSS IND3D4
XFE_RC_1685_0 FE_RN_926_0 FE_RN_924_0 VDD VSS INVD2
XFE_RC_1684_0 FE_RN_924_0 FE_OCPN1463_n3318 FE_RN_925_0 VDD VSS ND2D4
XFE_RC_1683_0 n135 n3316 FE_RN_926_0 VDD VSS ND2D3
XFE_RC_1682_0 n3318 FE_RN_926_0 FE_RN_927_0 VDD VSS IND2D2
XFE_RC_1681_0 FE_RN_927_0 FE_RN_925_0 shared_plane[18] VDD VSS ND2D8
XFE_RC_1680_0 FE_RN_453_0 n1789 FE_RN_923_0 VDD VSS IND2D4
XFE_RC_1679_0 FE_RN_923_0 n1787 base_plane[14] VDD VSS ND2D8
XFE_RC_1678_0 n2740 n236 n918 VDD VSS IND2D4
XFE_RC_1676_0 FE_RN_411_0 FE_OCPN1410_n1106 FE_RN_440_0 FE_RN_922_0 VDD VSS
+ OAI21D4
XFE_RC_1675_0 FE_RN_922_0 n3747 n806 VDD VSS CKND2D4
XFE_RC_1674_0 n2784 n2814 FE_RN_920_0 VDD VSS ND2D2
XFE_RC_1673_0 n924 FE_RN_921_0 VDD VSS INVD1
XFE_RC_1672_0 FE_RN_921_0 FE_RN_920_0 n2817 n923 VDD VSS IND3D4
XFE_RC_1666_0 n796 n795 n2756 VDD VSS ND2D2
XFE_RC_1665_0 n237 n795 n796 FE_RN_916_0 VDD VSS IND3D4
XFE_RC_1664_0 n793 FE_RN_917_0 VDD VSS INVD1
XFE_RC_1663_0 FE_RN_917_0 FE_RN_916_0 n2758 VDD VSS IND2D4
XFE_RC_1662_0 FE_RN_314_0 FE_RN_313_0 n3487 VDD VSS ND2D4
XFE_RC_1661_0 FE_RN_313_0 FE_RN_314_0 FE_RN_915_0 VDD VSS CKND2D4
XFE_RC_1660_0 FE_RN_915_0 FE_OCPN1178_n3485 n3386 FE_RN_94 VDD VSS AOI21D4
XFE_RC_1659_0 n1822 FE_RN_913_0 VDD VSS INVD1
XFE_RC_1658_0 FE_RN_913_0 FE_OFN72_n1925 FE_RN_914_0 VDD VSS IND2D4
XFE_RC_1657_0 n2184 FE_RN_133 FE_RN_914_0 n2181 VDD VSS OAI21D4
XFE_RC_1656_0 csa_carry_1[7] n865 VDD VSS INVD4
XFE_RC_1651_0 n3756 FE_RN_908_0 VDD VSS INVD1
XFE_RC_1650_0 FE_RN_908_0 n520 FE_RN_909_0 VDD VSS IND2D4
XFE_RC_1649_0 FE_RN_909_0 FE_RN_815_0 base_plane[17] VDD VSS ND2D8
XFE_RC_1648_0 FE_PSN1617_FE_OFN1126_x_0 FE_PSN1651_n304 n2695 VDD VSS NR2XD8
XFE_RC_1647_0 FE_RN_676_0 divided_plane[21] FE_RN_907_0 VDD VSS IND2D4
XFE_RC_1646_0 FE_RN_907_0 FE_RN_12_0 mantissa_value[21] VDD VSS CKND2D8
XFE_RC_1645_0 FE_RN_904_0 n76 FE_RN_902_0 VDD VSS ND2D2
XFE_RC_1644_0 n76 FE_RN_903_0 VDD VSS INVD1
XFE_RC_1643_0 FE_OCPN1290_n1150 n2038 FE_RN_904_0 VDD VSS CKND2D3
XFE_RC_1642_0 FE_RN_904_0 FE_RN_905_0 VDD VSS INVD1
XFE_RC_1641_0 FE_RN_905_0 FE_RN_903_0 FE_RN_906_0 VDD VSS ND2D2
XFE_RC_1640_0 FE_RN_906_0 FE_RN_902_0 shared_plane[5] VDD VSS ND2D8
XFE_RC_1639_0 n850 n848 FE_RN_901_0 VDD VSS CKND2D2
XFE_RC_1638_0 FE_RN_901_0 n1827 n832 VDD VSS ND2D2
XFE_RC_1635_0 FE_OCPN1231_n3457 FE_OCPN1318_n3456 n1616 VDD VSS INR2XD4
XFE_RC_1634_0 FE_RN_98_0 FE_RN_73 FE_RN_97_0 FE_RN_70 VDD VSS OAI21D4
XFE_RC_1633_0 FE_RN_98_0 FE_RN_73 FE_RN_97_0 FE_OCPN1177_n1248 VDD VSS OAI21D4
XFE_RC_1626_0 FE_RN_896_0 n933 FE_RN_895_0 VDD VSS CKND2D3
XFE_RC_1625_0 n2659 n935 FE_RN_896_0 VDD VSS CKND2D2
XFE_RC_1624_0 FE_RN_896_0 n933 FE_RN_895_0 n1624 VDD VSS OAI21D4
XFE_RC_1623_0 n2128 n2126 n1082 VDD VSS AN2D4
XFE_RC_1622_0 n3619 FE_RN_893_0 VDD VSS INVD1
XFE_RC_1621_0 n3597 n382 FE_RN_893_0 FE_RN_894_0 VDD VSS OAI21D4
XFE_RC_1620_0 FE_RN_675_0 FE_RN_894_0 n3854 VDD VSS INR2XD4
XFE_RC_1617_0 n3669 FE_RN_891_0 VDD VSS INVD2
XFE_RC_1616_0 n1427 n1429 FE_RN_891_0 n225 VDD VSS AOI21D4
XFE_RC_1615_0 n1961 n2090 FE_RN_889_0 VDD VSS CKND2D2
XFE_RC_1614_0 n1963 n1962 FE_RN_890_0 VDD VSS ND2D2
XFE_RC_1613_0 FE_RN_890_0 FE_RN_889_0 n1175 VDD VSS ND2D2
XFE_RC_1611_0 y_mantissa[5] n2708 VDD VSS CKND8
XFE_RC_1610_0 n2235 FE_RN_43 n2906 VDD VSS ND2D8
XFE_RC_1609_0 n2235 FE_RN_43 FE_OFN1383_n2906 VDD VSS ND2D8
XFE_RC_1608_0 n1885 n1884 FE_RN_887_0 VDD VSS ND2D1
XFE_RC_1607_0 FE_RN_887_0 n1888 FE_RN_888_0 VDD VSS ND2D2
XFE_RC_1606_0 n1887 FE_RN_888_0 n190 VDD VSS INR2XD2
XFE_RC_1605_0 n1995 n1996 FE_OFN1333_n1420 VDD VSS ND2D8
XFE_RC_1600_0 FE_RN_445_0 FE_RN_441_0 FE_RN_881_0 VDD VSS ND2D2
XFE_RC_1599_0 FE_RN_445_0 FE_RN_882_0 VDD VSS INVD1
XFE_RC_1598_0 FE_RN_882_0 FE_OCPN1400_FE_RN_56 FE_RN_883_0 VDD VSS ND2D2
XFE_RC_1597_0 FE_RN_883_0 FE_RN_881_0 n2698 VDD VSS ND2D3
XFE_RC_1596_0 n727 n2617 n2618 n341 VDD VSS ND3D8
XFE_RC_1595_0 FE_OCPN1457_FE_OFN2722_y_1 FE_OCPN11_y_2 n2040 n1225 VDD VSS
+ OAI21D4
XFE_RC_1592_0 n3740 FE_RN_403_0 base_plane[4] VDD VSS ND2D3
XFE_RC_1590_0 n2450 n2403 n1138 VDD VSS CKND2D4
XFE_RC_1587_0 n2454 n1179 n2456 VDD VSS ND2D8
XFE_RC_1586_0 n2454 n1179 FE_OFN1334_n2456 VDD VSS ND2D8
XFE_RC_1585_0 FE_RN_116 FE_RN_124 FE_RN_80 VDD VSS CKND2D4
XFE_RC_1584_0 n564 n565 n554 VDD VSS ND2D8
XFE_RC_1583_0 n565 n564 n1560 VDD VSS AN2D8
XFE_OCPC1412_n615 n615 FE_OCPN1412_n615 VDD VSS BUFFD4
XFE_RC_1577_0 FE_OCPN1275_n872 FE_RN_45 FE_RN_875_0 VDD VSS IND2D4
XFE_RC_1576_0 FE_OCPN1275_n872 FE_RN_876_0 VDD VSS INVD3
XFE_RC_1575_0 FE_RN_45 FE_RN_876_0 FE_RN_875_0 n1538 VDD VSS OAI21D4
XFE_RC_1574_0 n2296 n2434 FE_OCPN3442_n2435 FE_RN_871_0 VDD VSS OAI21D4
XFE_RC_1573_0 n2434 FE_RN_872_0 VDD VSS CKND4
XFE_RC_1572_0 n2296 FE_OCPN3442_n2435 FE_RN_873_0 VDD VSS NR2XD4
XFE_RC_1571_0 FE_RN_873_0 FE_RN_872_0 FE_RN_874_0 VDD VSS CKND2D4
XFE_RC_1570_0 FE_RN_874_0 FE_RN_871_0 FE_RN_59 n1065 VDD VSS ND3D8
XFE_RC_1569_0 FE_OCPN1440_FE_RN_44 FE_OCPN1449_n669 FE_RN_312_0 VDD VSS NR2D2
XFE_RC_1553_0 FE_RN_439_0 FE_RN_857_0 VDD VSS INVD1
XFE_RC_1552_0 FE_RN_437_0 FE_RN_75 FE_RN_858_0 VDD VSS IND2D4
XFE_RC_1551_0 FE_RN_858_0 FE_RN_857_0 n776 VDD VSS CKND2D4
XFE_RC_1550_0 FE_RN_703_0 FE_RN_855_0 VDD VSS INVD1
XFE_RC_1549_0 n3369 FE_RN_855_0 FE_RN_856_0 VDD VSS IND2D2
XFE_RC_1548_0 FE_RN_856_0 FE_RN_702_0 shared_plane[8] VDD VSS ND2D8
XFE_RC_1540_0 n1055 n2298 FE_RN_850_0 VDD VSS NR2D2
XFE_RC_1539_0 FE_RN_850_0 n155 n588 VDD VSS ND2D2
XFE_RC_1535_0 csa_sum_1[8] csa_carry_1[8] n1047 VDD VSS ND2D3
XFE_OCPC1411_n3330 n3330 FE_OCPN1411_n3330 VDD VSS BUFFD2
XFE_OCPC1410_n1106 n1106 FE_OCPN1410_n1106 VDD VSS BUFFD4
XFE_RC_1531_0 n3629 n879 n878 VDD VSS ND2D2
XFE_RC_1530_0 FE_RN_117 FE_RN_102 VDD VSS BUFFD4
XFE_RC_1529_0 n1050 FE_RN_117 n1543 n933 VDD VSS OAI21D4
XFE_RC_1528_0 n1620 FE_RN_56 n2744 FE_RN_48 VDD VSS OAI21D4
XFE_RC_1527_0 n361 FE_OFN2786_n3022 FE_RN_845_0 VDD VSS IND2D2
XFE_RC_1526_0 n360 FE_OFN2786_n3022 FE_RN_845_0 n358 VDD VSS OAI21D4
XFE_RC_1525_0 n2179 n354 FE_RN_791_0 VDD VSS NR2D4
XFE_RC_1524_0 n2314 FE_RN_843_0 VDD VSS INVD1
XFE_RC_1523_0 FE_RN_843_0 n141 FE_RN_844_0 VDD VSS IND2D4
XFE_RC_1522_0 FE_RN_844_0 n143 n1356 VDD VSS ND2D4
XFE_RC_1059_0_dup n3631 n3629 n3632 FE_RN_156 VDD VSS OAI21D4
XFE_RC_1521_0 n2443 FE_OCPN1242_n2652 n1699 n808 VDD VSS OAI21D4
XFE_RC_1520_0 n383 n1841 n2831 VDD VSS CKND2D8
XFE_RC_1519_0 n383 n1841 FE_OFN1374_n2831 VDD VSS ND2D4
XU2817_dup2 n882 n2464 FE_RN_156 FE_RN_155 VDD VSS AOI21D4
XFE_RC_1517_0 n3554 FE_RN_840_0 VDD VSS INVD2
XFE_RC_1516_0 FE_RN_840_0 n1317 FE_RN_841_0 VDD VSS IND2D2
XFE_RC_1515_0 FE_RN_841_0 FE_RN_104 FE_RN_842_0 VDD VSS IND2D4
XFE_RC_1514_0 FE_RN_842_0 n35 n34 VDD VSS ND2D4
XU1029_dup n982 n1069 FE_RN_144 VDD VSS AN2D4
XFE_RC_1512_0 n2176 FE_RN_839_0 VDD VSS CKND2
XFE_RC_1511_0 FE_RN_839_0 n2175 FE_RN_309_0 VDD VSS CKND2D2
XFE_RC_1510_0 n3341 FE_RN_837_0 VDD VSS INVD1
XFE_RC_1509_0 FE_RN_837_0 FE_RN_128 FE_RN_838_0 VDD VSS IND2D4
XFE_RC_1508_0 FE_RN_838_0 n1417 n1416 VDD VSS CKND2D4
XFE_RC_1507_0 FE_RN_385_0 FE_RN_835_0 VDD VSS INVD1
XFE_RC_1506_0 FE_RN_835_0 n1850 FE_RN_836_0 VDD VSS IND2D4
XFE_RC_1505_0 FE_RN_387_0 n1850 FE_RN_836_0 n1149 VDD VSS OAI21D4
XFE_OCPC1380_n3128 n1644 FE_OCPN3519_n3128 VDD VSS CKND12
XFE_OCPC1379_n3128 n3268 FE_OCPN3518_n3128 VDD VSS INVD6
XFE_OCPC1378_n3128 n3268 FE_OCPN3517_n3128 VDD VSS INVD8
XFE_OCPC1377_n3128 n3268 FE_OCPN3516_n3128 VDD VSS CKND1
XFE_OCPC1376_n3128 n1643 n2482 VDD VSS INVD3
XFE_OCPC1375_n3128 n2416 n2430 VDD VSS CKND6
XFE_OCPC1374_n3128 n3253 n2689 VDD VSS CKND1
XFE_OCPC1373_n3128 n3253 n2777 VDD VSS BUFFD8
XFE_OCPC1372_n3128 n3253 n1689 VDD VSS CKND4
XFE_OCPC1371_n3128 n394 n1644 VDD VSS CKND16
XFE_OCPC1370_n3128 n394 n3810 VDD VSS CKND4
XFE_OCPC1369_n3128 n394 n3268 VDD VSS CKND12
XFE_OCPC1368_n3128 FE_OCPN1464_n2628 FE_OFN1367_n1643 VDD VSS BUFFD3
XFE_OCPC1367_n3128 n2598 n1643 VDD VSS CKND2
XFE_OCPC1366_n3128 n2598 n2416 VDD VSS CKND2
XFE_OCPC1365_n3128 n2598 n3253 VDD VSS INVD6
XFE_OCPC1364_n3128 n2598 n394 VDD VSS INVD12
XFE_OCPC1363_n3128 n3128 n3626 VDD VSS BUFFD8
XFE_OCPC1362_n3128 FE_OCPN1433_n3128 n2628 VDD VSS CKND4
XFE_OCPC1361_n3128 n3128 n2598 VDD VSS CKND12
XFE_RC_1497_0 FE_RN_57 n1851 VDD VSS INVD6
XU3288_dup n2840 n1726 n68 n3289 FE_RN_154 VDD VSS OAI22D4
XFE_OCPC1409_csa_sum_1_15 csa_sum_1[15] FE_OCPN1409_csa_sum_1_15 VDD VSS CKBD4
XFE_RC_730_0_dup FE_RN_405_0 n744 FE_RN_92 VDD VSS IND2D4
XFE_OFC1360_n647_dup1 FE_RN_71 FE_RN_89 VDD VSS BUFFD4
XFE_RC_1478_0 n1070 n1349 FE_RN_816_0 VDD VSS CKND2D4
XFE_RC_1477_0 n1348 n3243 FE_RN_816_0 FE_RN_181_0 VDD VSS IND3D4
XFE_RC_1476_0 n2111 FE_RN_814_0 VDD VSS INVD1
XFE_RC_1475_0 FE_RN_814_0 n364 FE_RN_815_0 VDD VSS IND2D4
XFE_OCPC1360_n937 FE_OFN1363_n937 FE_RN_103 VDD VSS CKND12
XFE_OCPC1359_n937 n937 FE_OFN1363_n937 VDD VSS INVD6
XFE_RC_1472_0 n218 n1089 FE_RN_813_0 VDD VSS NR2XD1
XFE_RC_1471_0 FE_RN_813_0 n1090 n1345 n2226 VDD VSS ND3D3
XFE_RC_1470_0 n1053 FE_OFN1365_n1053 VDD VSS CKBD4
XFE_RC_1469_0 n1053 n1048 n2704 VDD VSS CKND2D8
XFE_RC_1468_0 n605 FE_OFN68_n605 VDD VSS CKBD4
XFE_RC_1467_0 n605 FE_OFN1355_n605 VDD VSS CKBD4
XFE_RC_1466_0 FE_RN_131 FE_RN_39 VDD VSS CKBD4
XFE_RC_1465_0 n1591 FE_RN_131 n1673 VDD VSS NR2XD8
XFE_RC_1464_0 FE_OFN64_n107 FE_OFN1351_n107 VDD VSS INVD8
XFE_RC_1463_0 FE_OCPN1442_FE_RN_812_0 FE_RN_808_0 VDD VSS INVD1
XFE_RC_1462_0 FE_PSN1650_n3355 FE_RN_809_0 VDD VSS INVD1
XFE_RC_1461_0 FE_RN_809_0 FE_RN_808_0 n3360 VDD VSS INR2XD1
XFE_RC_1460_0 n3355 FE_RN_810_0 VDD VSS INVD1
XFE_RC_1459_0 n1650 FE_RN_811_0 VDD VSS CKND2
XFE_RC_1458_0 FE_RN_811_0 n3477 FE_RN_812_0 VDD VSS IND2D4
XFE_RC_1457_0 FE_RN_812_0 FE_RN_810_0 FE_RN_9_0 FE_RN_10_0 VDD VSS ND3D8
XFE_RC_1436_0 n1840 FE_RN_792_0 VDD VSS INVD1
XFE_RC_1435_0 FE_RN_792_0 FE_RN_791_0 n1832 VDD VSS IND2D4
XFE_RC_1434_0 n2740 FE_RN_55 n547 VDD VSS IND2D4
XU2916_dup n842 n841 FE_RN_153 VDD VSS ND2D4
XFE_OCPC1358_FE_OFN21_x_6 FE_RN_129 FE_OCPN3515_FE_OFN21_x_6 VDD VSS CKND2
XFE_OCPC1357_FE_OFN21_x_6 FE_RN_129 n1719 VDD VSS CKND2
XFE_OCPC1356_FE_OFN21_x_6 FE_RN_129 n473 VDD VSS CKND16
XFE_OCPC1355_FE_OFN21_x_6 FE_OCPN13_FE_OFN21_x_6 n2753 VDD VSS BUFFD4
XFE_OCPC1354_FE_OFN21_x_6 FE_OCPN13_FE_OFN21_x_6 FE_OCPN3460_n2753 VDD VSS
+ CKBD1
XFE_OCPC1353_FE_OFN21_x_6 x_mantissa[6] FE_RN_129 VDD VSS INVD8
XFE_OCPC1407_n2719 n2719 FE_OCPN1407_n2719 VDD VSS BUFFD4
XFE_OCPC1350_n1563 FE_RN_4 FE_OFN71_n1563 VDD VSS BUFFD4
XFE_OCPC1349_n1563 n1563 FE_RN_4 VDD VSS BUFFD12
XFE_OCPC1348_n2554 FE_RN_262_0 FE_OFN1372_n2554 VDD VSS INVD2
XFE_OCPC1347_n2554 n2554 FE_RN_81 VDD VSS CKND2
XFE_OCPC1346_n2554 n2554 FE_RN_262_0 VDD VSS CKND2
XU509_dup n2704 n981 FE_RN_152 VDD VSS XOR2D4
XFE_RC_1427_0 FE_RN_153 FE_PSN1644_n3331 FE_RN_316_0 FE_RN_315_0 FE_RN_785_0
+ VDD VSS OAI211D4
XFE_RC_1426_0 FE_RN_785_0 FE_RN_320_0 base_plane[8] VDD VSS ND2D8
XFE_OCPC1345_n1686 n1567 n2555 VDD VSS BUFFD4
XFE_OCPC1344_n1686 FE_OFN1368_n1686 n1567 VDD VSS CKND16
XFE_OCPC1343_n1686 n1686 FE_OFN1368_n1686 VDD VSS INVD8
XFE_RC_1425_0 n1903 n2768 n2148 VDD VSS IND2D4
XU2676_dup n2752 n304 FE_RN_151 VDD VSS NR2D2
XFE_RC_1424_0 n2681 FE_RN_781_0 VDD VSS INVD1
XU830_dup n3038 FE_RN_150 VDD VSS INVD6
XFE_RC_1417_0 FE_RN_130 n138 FE_OFN1336_n375 VDD VSS ND2D4
XU2438_dup n166 n1644 FE_RN_149 VDD VSS INR2D4
XU884_dup FE_RN_127 n488 FE_RN_147 VDD VSS CKND2D4
XFE_RC_265_0_dup FE_OFN70_n1339 n2723 n324 FE_RN_145 VDD VSS AOI21D4
XFE_RC_1416_0 n365 FE_RN_424_0 FE_RN_423_0 n364 VDD VSS OAI21D4
XFE_RC_1415_0 n552 FE_RN_121_0 n551 n884 VDD VSS ND3D8
XFE_RC_1412_0 n2513 FE_PSN1641_n2517 FE_RN_779_0 VDD VSS ND2D2
XFE_RC_1411_0 FE_RN_779_0 n2511 n1978 VDD VSS ND2D2
XFE_RC_1410_0 FE_RN_712_0 FE_RN_713_0 n609 FE_OCPN1488_n1927 FE_RN_714_0 VDD
+ VSS AOI22D2
XFE_OCPC1342_FE_RN_63 n2652 n1792 VDD VSS BUFFD12
XFE_OCPC1341_FE_RN_63 n2557 n86 VDD VSS CKND4
XFE_OCPC1340_FE_RN_63 n2557 FE_OCPN1242_n2652 VDD VSS INVD3
XFE_OCPC1339_FE_RN_63 FE_RN_63 n2652 VDD VSS INVD6
XFE_OCPC1338_FE_RN_63 FE_RN_63 n2557 VDD VSS INVD4
XFE_OCPC1337_FE_RN_63 FE_RN_63 n1098 VDD VSS CKND8
XFE_OCPC1336_n1018 n1018 FE_OFN1364_n1018 VDD VSS BUFFD4
XU2699_dup n639 n3638 FE_RN_143 VDD VSS ND2D4
XFE_OCPC1335_n239 n1015 n78 VDD VSS CKND1
XFE_OCPC1334_n239 n1015 n1759 VDD VSS INVD3
XFE_OCPC1333_n239 n74 n1015 VDD VSS CKND6
XFE_OCPC1332_n239 FE_OCPN12_n239 n74 VDD VSS INVD6
XFE_OCPC1331_n239 FE_OCPN12_n239 FE_RN_210_0 VDD VSS CKND12
XFE_OCPC1329_n239 y_mantissa[3] FE_OCPN3467_y_3 VDD VSS INVD6
XU622_dup n1628 n2077 FE_RN_142 VDD VSS CKND2D8
XFE_OFC868_x_2_dup x_mantissa[2] FE_RN_141 VDD VSS INVD8
XU408_dup n1812 n616 FE_RN_140 VDD VSS OR2XD1
XFE_RC_1406_0 n823 FE_RN_775_0 VDD VSS INVD1
XFE_RC_1405_0 n741 FE_RN_775_0 FE_RN_776_0 VDD VSS NR2XD4
XFE_RC_1404_0 FE_RN_776_0 n805 FE_RN_777_0 VDD VSS ND2D3
XFE_RC_1403_0 FE_RN_777_0 n2120 n969 VDD VSS ND2D4
XFE_RC_1402_0 n1620 n3532 n2744 n3521 VDD VSS OAI21D4
XFE_RC_1400_0 n3350 FE_RN_72_0 FE_RN_71_0 n3455 VDD VSS OAI21D4
XFE_OFC1369_n1851_dup n1851 FE_RN_139 VDD VSS BUFFD4
XU710_dup n429 n3752 FE_RN_138 VDD VSS ND2D4
XFE_RC_790_0_dup FE_RN_23 n1798 n1796 FE_RN_136 VDD VSS AOI21D4
XU2478_dup n2248 n951 FE_RN_135 VDD VSS ND2D4
XFE_RC_239_0_dup n1303 FE_RN_130_0 FE_RN_129_0 FE_RN_134 VDD VSS OAI21D4
XFE_OCPC1327_y_2 FE_OFN75_n2718 FE_OCPN3510_y_2 VDD VSS CKND6
XFE_OCPC1326_y_2 FE_OFN75_n2718 FE_OCPN3509_y_2 VDD VSS INVD4
XFE_OCPC1325_y_2 FE_OCPN1298_n2718 FE_OCPN3508_y_2 VDD VSS INVD8
XFE_OCPC1324_y_2 FE_OCPN1298_n2718 FE_OCPN1172_n668 VDD VSS CKND1
XFE_OCPC1323_y_2 FE_OCPN10_y_2 n2718 VDD VSS CKND4
XFE_OCPC1321_y_2 FE_OCPN10_y_2 FE_OFN75_n2718 VDD VSS BUFFD12
XFE_OCPC1320_y_2 n102 FE_OCPN1225_n2718 VDD VSS CKND2
XFE_OCPC1319_y_2 n102 FE_OCPN1298_n2718 VDD VSS CKND4
XFE_OCPC1317_y_2 y_mantissa[2] n102 VDD VSS INVD6
XFE_RC_1381_0 n3686 n3567 FE_RN_759_0 VDD VSS NR2XD3
XFE_RC_1380_0 n2176 FE_RN_759_0 n396 VDD VSS ND2D4
XFE_OFC72_n1925_dup n1925 FE_RN_133 VDD VSS BUFFD4
XFE_RC_116_0_dup FE_OCPN1195_n2831 FE_RN_64_0 FE_RN_63_0 FE_RN_132 VDD VSS
+ OAI21D4
XFE_RC_1379_0 FE_OFN74_n2653 n2109 n2108 n2899 VDD VSS AOI21D4
XFE_RC_1358_0_dup n2719 n1098 FE_RN_131 VDD VSS ND2D8
XFE_RC_675_0_dup n152 FE_RN_378_0 FE_RN_377_0 FE_RN_26 VDD VSS AOI21D4
XFE_RC_1378_0 n562 n1248 n525 VDD VSS NR2D3
XFE_OCPC1315_x_4 FE_OCPN9_x_4 n106 VDD VSS BUFFD4
XFE_OCPC1314_x_4 FE_OCPN9_x_4 FE_RN_121 VDD VSS INVD2
XFE_OCPC1313_x_4 x_mantissa[4] FE_RN_82 VDD VSS BUFFD8
XFE_OCPC1312_x_4 x_mantissa[4] FE_OFN1366_n1641 VDD VSS BUFFD8
XU1164_dup x_mantissa[0] FE_RN_141 FE_RN_130 VDD VSS IND2D4
XU1031_dup FE_RN_69 FE_RN_150 FE_RN_128 VDD VSS ND2D8
XFE_OCPC1309_n2899 FE_RN_8 FE_OCPN1148_n2899 VDD VSS INVD4
XFE_OCPC1308_n2899 FE_RN_83 FE_RN_8 VDD VSS INVD6
XFE_OCPC1307_n2899 FE_RN_83 n2671 VDD VSS INVD6
XFE_OCPC1306_n2899 FE_RN_83 FE_OFN1352_n2899 VDD VSS INVD4
XFE_OCPC1305_n2899 n2899 FE_OFN100_n2899 VDD VSS BUFFD3
XFE_OCPC1304_n2899 n2899 FE_RN_83 VDD VSS INVD6
XFE_RC_1376_0 n566 n3356 n3357 n3351 VDD VSS OAI21D4
XU2579_dup n998 FE_OCPN1592_n1690 n1779 FE_RN_127 VDD VSS OAI21D4
XU500_dup n1584 n2056 FE_RN_126 VDD VSS ND2D4
XFE_OFC1338_n3744_dup n3744 FE_RN_125 VDD VSS BUFFD4
XU3630_dup n473 n1685 FE_RN_124 VDD VSS ND2D8
XFE_OFC544_n2450_dup FE_OFN108_n2450 FE_RN_123 VDD VSS INVD16
XFE_OCPC1177_n1248_dup FE_RN_70 FE_RN_106 VDD VSS BUFFD4
XFE_OCPC1303_n2719 FE_OFN3500_n2719 FE_RN_109 VDD VSS BUFFD4
XFE_OCPC1302_n2719 FE_RN_105 FE_OFN3502_n2719 VDD VSS INVD4
XFE_OCPC1301_n2719 FE_RN_105 FE_OFN3500_n2719 VDD VSS INVD8
XFE_OCPC1300_n2719 n2719 FE_RN_105 VDD VSS INVD8
XU31_dup csa_sum_1[22] csa_carry_1[22] FE_RN_120 VDD VSS NR2XD4
XU773_dup n1507 FE_RN_4 FE_RN_119 VDD VSS ND2D8
XU3534_dup n1691 n2709 FE_RN_118 VDD VSS XNR2D4
XU1152_dup n1301 n138 FE_RN_117 VDD VSS CKND2D4
XU2566_dup1 n941 FE_RN_82 FE_RN_116 VDD VSS ND2D8
XU1108_dup FE_RN_25 FE_RN_115 VDD VSS INVD4
XFE_OCPC1299_n1106 FE_OFN1382_n1106 FE_OCPN1395_n1106 VDD VSS INVD12
XFE_OCPC1298_n1106 n1106 FE_OFN1382_n1106 VDD VSS INVD8
XFE_OCPC1297_FE_RN_51 n1850 n116 VDD VSS INVD8
XFE_OCPC1296_FE_RN_51 FE_RN_51 n113 VDD VSS INVD1
XFE_OCPC1295_FE_RN_51 FE_RN_51 n1850 VDD VSS INVD6
XU3334_dup1 FE_OCPN1446_FE_RN_45 FE_OCPN1275_n872 FE_RN_114 VDD VSS CKXOR2D4
XU2405_dup n366 n1529 FE_RN_113 VDD VSS CKND2D4
XFE_RC_509_0_dup FE_RN_29 n1676 x_mantissa[21] FE_RN_112 VDD VSS OAI21D4
XFE_OFC1370_n1924_dup n1924 FE_RN_111 VDD VSS BUFFD4
XU2829_dup n278 n1370 n1208 FE_RN_110 VDD VSS AOI21D4
XFE_OCPC1290_y_0 y_mantissa[0] FE_OCPN3505_y_0 VDD VSS INVD6
XU1987_dup1 n1025 n1024 FE_RN_107 VDD VSS ND2D4
XU3114_dup n3552 FE_OCPN1395_n1106 FE_RN_104 VDD VSS IND2D4
XU2476_dup n562 FE_OCPN1177_n1248 FE_RN_100 VDD VSS ND2D4
XFE_OFC816_n2883_dup FE_RN_120 FE_RN_99 VDD VSS INVD4
XU3110_dup n1102 n1101 FE_RN_98 VDD VSS CKND2D4
XU138_dup n1351 n3616 n1350 FE_RN_97 VDD VSS OAI21D4
XU2720_dup n1392 FE_RN_132 FE_RN_78 VDD VSS INR2D4
XFE_RC_1358_0 FE_OCPN1407_n2719 n2652 n699 VDD VSS ND2D8
XU733_dup FE_RN_119 n1200 FE_RN_96 VDD VSS CKND2D8
XU1027_dup n2644 n1474 n2645 FE_RN_95 VDD VSS OAI21D4
XU1077_dup n1464 n1304 FE_RN_93 VDD VSS IND2D4
XU2971_dup n963 n1027 n221 n1333 FE_RN_91 VDD VSS AOI22D4
XU686_dup n2012 n2482 n194 FE_RN_90 VDD VSS AOI21D4
XU272_dup n3107 FE_OFN2726_n107 n2870 n2869 FE_RN_88 VDD VSS OAI211D4
XFE_RC_830_0_dup n1256 n152 FE_RN_87 VDD VSS IND2D4
XU3078_dup1 n1021 n3384 n3365 FE_RN_86 VDD VSS OAI21D4
XU2817_dup1 n882 n2464 n782 FE_RN_85 VDD VSS AOI21D4
XU801_dup n1007 n2074 n2178 FE_RN_84 VDD VSS AOI21D4
XFE_RC_15_0_dup n1755 n2849 n2848 FE_RN_79 VDD VSS OAI21D4
XU3526_dup n3477 FE_OCPN1549_n1650 FE_OCPN1466_n3355 FE_RN_77 VDD VSS AOI21D4
XU944_dup1 FE_RN_86 FE_RN_107 n1023 FE_RN_76 VDD VSS AOI21D4
XFE_OFC1386_n1629_dup n1629 FE_RN_73 VDD VSS BUFFD4
XU943_dup FE_RN_76 n2966 n883 FE_RN_72 VDD VSS OAI21D4
XU930_dup FE_OFN106_n1673 n2071 FE_RN_71 VDD VSS CKND2D4
XU1032_dup FE_OCPN1395_n1106 n524 FE_RN_69 VDD VSS CKND2D8
XFE_OCPC1401_n2887 n2887 FE_OCPN1401_n2887 VDD VSS BUFFD2
XFE_OCPC1400_FE_RN_56 FE_RN_56 FE_OCPN1400_FE_RN_56 VDD VSS BUFFD4
XFE_OFC1360_n647_dup FE_RN_71 FE_RN_68 VDD VSS BUFFD4
XFE_RC_135_0_dup FE_RN_74_0 FE_RN_67 VDD VSS CKND4
XFE_OCPC1397_n3351 n3351 FE_OCPN1397_n3351 VDD VSS BUFFD2
XFE_OCPC1394_n727 FE_RN_96 FE_OCPN1394_n727 VDD VSS BUFFD4
XFE_OCPC1393_n3350 n3350 FE_OCPN1393_n3350 VDD VSS BUFFD4
XFE_OCPC1391_FE_OFN68_n605 FE_OFN68_n605 FE_OCPN1391_FE_OFN68_n605 VDD VSS
+ BUFFD4
XU924_dup n341 n31 FE_RN_66 VDD VSS ND2D3
XFE_RC_1354_0 n916 n251 n2211 n812 VDD VSS ND3D3
XFE_OFC1386_n1629 n1629 FE_OFN1386_n1629 VDD VSS BUFFD4
XFE_OFC1275_n261 n261 FE_OFN3496_n261 VDD VSS BUFFD4
XFE_OFC1267_n3837 n3837 FE_OFN3488_n3837 VDD VSS CKBD0
XFE_OFC1266_n3408 n3408 FE_OFN3487_n3408 VDD VSS BUFFD3
XFE_OFC1376_n3256 n3256 FE_OFN1376_n3256 VDD VSS CKBD1
XFE_OFC1375_n3252 n3252 FE_OFN1375_n3252 VDD VSS CKBD1
XFE_OFC1265_n3239 n3239 FE_OFN3486_n3239 VDD VSS CKBD4
XFE_OFC1264_n3071 n3071 FE_OFN3485_n3071 VDD VSS CKBD0
XFE_OFC1370_n1924 n1924 FE_OFN1370_n1924 VDD VSS BUFFD4
XFE_OFC1369_n1851 n1851 FE_OFN1369_n1851 VDD VSS BUFFD16
XFE_OFC1362_n766 n766 FE_OFN1362_n766 VDD VSS BUFFD8
XFE_OFC1361_n727 FE_RN_96 FE_OFN1361_n727 VDD VSS BUFFD4
XFE_OFC1360_n647 n647 FE_OFN1360_n647 VDD VSS BUFFD8
XFE_OFC1359_n323 n323 FE_OFN1359_n323 VDD VSS BUFFD2
XFE_OFC1263_n296 n296 FE_OFN3484_n296 VDD VSS CKBD0
XFE_OFC1262_n59 FE_OFN3482_n59 FE_OFN3483_n59 VDD VSS CKND6
XFE_OFC1261_n59 n59 FE_OFN3482_n59 VDD VSS CKND6
XFE_OFC1260_n59 n59 FE_OFN3481_n59 VDD VSS CKBD4
XFE_OFC1259_n46 n46 FE_OFN3480_n46 VDD VSS BUFFD1
XFE_OFC1354_n2417 FE_OFN73_n2417 FE_OFN1354_n2417 VDD VSS CKBD1
XFE_OFC1350_n2457 FE_OFN2777_n2457 FE_OFN1350_n2457 VDD VSS BUFFD8
XFE_OFC1257_FE_OFN3423_n1728 FE_OFN3423_n1728 FE_OFN3478_FE_OFN3423_n1728 VDD
+ VSS CKBD0
XFE_OFC1349_FE_RN_56 FE_RN_56 FE_OFN1349_FE_RN_56 VDD VSS BUFFD4
XFE_OFC1337_n1794 n1794 FE_OFN1337_n1794 VDD VSS BUFFD4
XFE_OCPC1255_n80 n80 FE_OCPN3476_n80 VDD VSS BUFFD8
XFE_RC_1332_0 n1823 FE_RN_733_0 VDD VSS CKND2
XFE_RC_1331_0 n2114 FE_RN_733_0 FE_RN_734_0 VDD VSS ND2D2
XFE_RC_1330_0 n1823 FE_RN_735_0 VDD VSS CKND2
XFE_RC_1329_0 n2114 FE_RN_735_0 FE_RN_734_0 n27 VDD VSS OAI21D2
XFE_RC_1328_0 FE_RN_19 n2269 n537 VDD VSS AN2D4
XU3211_dup n3217 n1332 n1331 FE_RN_65 VDD VSS OAI21D1
XFE_RC_1327_0 n2760 n2456 n376 FE_RN_732_0 VDD VSS IND3D4
XFE_RC_1326_0 FE_RN_732_0 FE_OFN1350_n2457 n991 VDD VSS CKND2D4
XFE_OCPC1254_FE_OFN1124_y_4 FE_OCPN1275_n872 FE_OCPN3468_n VDD VSS BUFFD4
XFE_OCPC1253_FE_OFN1124_y_4 n2075 FE_OCPN1275_n872 VDD VSS CKND12
XFE_OCPC1252_FE_OFN1124_y_4 n2075 n872 VDD VSS INVD4
XFE_OCPC1251_FE_OFN1124_y_4 FE_OCPN1_y_4 n2075 VDD VSS BUFFD8
XFE_OCPC1248_n667 FE_OFN0_y_1 n67 VDD VSS INVD6
XFE_RC_1314_0 FE_OCPN1296_n2751 n766 n312 FE_RN_90 n1132 VDD VSS OAI211D4
XU3220_dup n3217 n2472 n2471 FE_RN_64 VDD VSS OAI21D4
XFE_RC_1313_0 FE_RN_32_0 FE_RN_724_0 VDD VSS CKND2
XFE_RC_1312_0 FE_RN_724_0 FE_RN_256_0 selected_delta_3[14] VDD VSS NR2D4
XFE_RC_1311_0 FE_OCPN1242_n2652 n2443 n1338 n1336 VDD VSS OAI21D4
XFE_RC_1306_0 n1601 n554 FE_RN_722_0 VDD VSS ND2D2
XFE_RC_1305_0 FE_RN_722_0 n1602 n2110 VDD VSS ND2D4
XFE_RC_1304_0 n106 n974 FE_RN_720_0 VDD VSS IND2D4
XFE_RC_1303_0 FE_OCPN9_x_4 FE_RN_721_0 VDD VSS CKND2
XFE_RC_1302_0 n974 FE_RN_721_0 FE_RN_720_0 n2741 VDD VSS OAI21D4
XFE_OCPC1242_n178 FE_OCPN3474_n178 FE_OCPN3475_n178 VDD VSS CKND8
XFE_OCPC1236_n178 n178 FE_OCPN3474_n178 VDD VSS INVD12
XFE_OCPC1331_FE_OFN2808_shared_plane_22 FE_OFN2808_shared_plane_22
+ FE_OCPN1331_FE_OFN2808_shared_plane_22 VDD VSS CKBD0
XFE_OCPC1233_shared_plane_24 shared_plane[24] FE_OCPN3472_shared_plane_24 VDD
+ VSS BUFFD3
XFE_OCPC1226_shared_plane_25 shared_plane[25] FE_OCPN3470_shared_plane_25 VDD
+ VSS BUFFD8
XU1026_dup FE_OCPN3467_y_3 FE_OCPN10_y_2 FE_RN_63 VDD VSS CKND2D8
XFE_RC_1294_0 n77 n2719 FE_RN_45 VDD VSS IND2D4
XFE_RC_1293_0 n77 n2719 FE_RN_6 VDD VSS IND2D4
XFE_RC_1292_0 n669 FE_RN_44 n3490 FE_RN_17 VDD VSS OAI21D4
XU795_dup FE_RN_6 n1064 FE_RN_57 VDD VSS NR2XD4
XFE_RC_1291_0 n376 FE_OFN2777_n2457 FE_OFN1334_n2456 n186 VDD VSS ND3D8
XFE_RC_1290_0 n1956 n2456 FE_OFN1350_n2457 FE_RN_718_0 VDD VSS ND3D8
XFE_RC_1289_0 n376 FE_RN_718_0 n992 VDD VSS INR2XD4
XFE_RC_1288_0 n993 n992 FE_RN_717_0 VDD VSS ND2D4
XFE_RC_1287_0 FE_RN_717_0 FE_RN_176_0 n556 VDD VSS ND2D4
XFE_RC_1285_0 n1316 n1943 FE_RN_716_0 VDD VSS CKND2D4
XFE_RC_1284_0 n928 FE_RN_716_0 n1219 VDD VSS ND2D4
XFE_RC_1283_0 FE_RN_66 n3656 n268 n873 VDD VSS AOI21D4
XFE_RC_1282_0 n2841 n1705 n3110 n633 VDD VSS ND3D3
XFE_RC_1281_0 n236 FE_RN_715_0 VDD VSS INVD2
XFE_RC_1280_0 FE_RN_715_0 FE_OCPN1428_n2740 n2745 n862 VDD VSS OAI21D4
XFE_RC_1279_0 n260 FE_RN_711_0 VDD VSS INVD1
XFE_RC_1278_0 n609 FE_RN_712_0 VDD VSS INVD2
XFE_RC_1277_0 n1927 FE_RN_713_0 VDD VSS INVD1
XFE_RC_1275_0 FE_RN_714_0 FE_RN_711_0 n2322 VDD VSS NR2D3
XFE_RC_1274_0 FE_RN_413_0 FE_RN_710_0 VDD VSS CKND2
XFE_RC_1273_0 n942 n3523 FE_RN_710_0 n7 VDD VSS ND3D8
XFE_RC_1264_0 n3661 FE_RN_92 n2962 n2964 VDD VSS AOI21D4
XFE_RC_1263_0 n3368 FE_RN_701_0 VDD VSS CKND1
XFE_RC_1262_0 n3369 FE_RN_701_0 FE_RN_702_0 VDD VSS CKND2D3
XFE_RC_1261_0 n3368 FE_RN_703_0 VDD VSS CKND2
XFE_RC_1259_0 n3252 FE_RN_698_0 VDD VSS CKND2
XFE_RC_1258_0 n2083 FE_RN_698_0 FE_RN_699_0 VDD VSS CKND2D2
XFE_RC_1257_0 n3252 FE_RN_700_0 VDD VSS CKND2
XFE_RC_1256_0 n2083 FE_RN_700_0 FE_RN_699_0 n2264 VDD VSS OAI21D2
XFE_RC_1255_0 n2677 n3729 n1783 n1220 VDD VSS ND3D3
XFE_RC_1253_0 n2692 n2555 n2690 n2691 FE_RN_697_0 VDD VSS OAI211D4
XFE_RC_1252_0 FE_RN_697_0 n2590 n1216 VDD VSS ND2D4
XFE_RC_1251_0 n3455 n3316 FE_RN_696_0 VDD VSS ND2D2
XFE_RC_1250_0 n3454 FE_RN_696_0 n3459 VDD VSS IND2D4
XFE_RC_1242_0 n732 n733 n731 n730 VDD VSS ND3D3
XFE_OCPC1327_n1069 n1069 FE_OCPN1327_n1069 VDD VSS BUFFD2
XFE_RC_1241_0 n571 FE_RN_114_0 FE_RN_113_0 FE_RN_686_0 VDD VSS OAI21D4
XFE_RC_1240_0 FE_OFN2745_y_20 FE_OFN2741_x_11 FE_RN_693_0 VDD VSS CKAN2D2
XFE_RC_1239_0 FE_RN_693_0 n1326 n2467 VDD VSS IND2D4
XFE_RC_1236_0 FE_OCPN1527_n1053 FE_RN_692_0 VDD VSS INVD4
XFE_RC_1235_0 FE_RN_692_0 n1685 n1053 n2709 n2746 VDD VSS AOI22D4
XFE_RC_1233_0 n1470 n1469 n1468 n1748 VDD VSS ND3D3
XFE_OCPC1214_n3734 n3734 FE_OCPN3465_n3734 VDD VSS CKBD1
XFE_RC_1232_0 FE_RN_665_0 FE_RN_666_0 n2428 n1185 n1194 VDD VSS AOI22D2
XFE_RC_1231_0 n263 n2694 FE_RN_691_0 VDD VSS ND2D4
XFE_RC_1230_0 n263 n2694 FE_RN_691_0 n1794 VDD VSS OAI21D4
XFE_RC_1229_0 n3184 FE_RN_688_0 VDD VSS CKND1
XFE_RC_1228_0 n43 FE_RN_688_0 FE_RN_689_0 VDD VSS ND2D2
XFE_RC_1227_0 n3184 FE_RN_690_0 VDD VSS CKND2
XFE_RC_1226_0 n43 FE_RN_690_0 FE_RN_689_0 n3207 VDD VSS OAI21D4
XFE_RC_1224_0 n3756 FE_RN_687_0 VDD VSS INVD1
XFE_RC_1223_0 FE_RN_687_0 FE_RN_686_0 n569 VDD VSS IND2D4
XFE_RC_1222_0 FE_RN_271_0 n1420 n3717 FE_RN_685_0 VDD VSS OAI21D4
XFE_RC_1221_0 FE_RN_270_0 FE_RN_685_0 n2301 VDD VSS INR2XD4
XFE_RC_1220_0 FE_RN_23 FE_RN_681_0 VDD VSS CKND2
XFE_RC_1219_0 FE_RN_681_0 FE_RN_118_0 FE_RN_682_0 VDD VSS IND2D2
XFE_RC_1218_0 n612 n1829 FE_RN_683_0 VDD VSS ND2D2
XFE_RC_1217_0 n3607 FE_RN_684_0 VDD VSS INVD1
XFE_RC_1216_0 FE_RN_684_0 FE_RN_683_0 FE_RN_682_0 n831 VDD VSS IND3D4
XFE_RC_1215_0 n3000 FE_RN_678_0 VDD VSS CKND1
XFE_RC_1214_0 n908 FE_RN_678_0 FE_RN_679_0 VDD VSS ND2D2
XFE_RC_1213_0 n3000 FE_RN_680_0 VDD VSS CKND1
XFE_RC_1212_0 n908 FE_RN_680_0 FE_RN_679_0 n3040 VDD VSS OAI21D4
XFE_RC_1211_0 n50 FE_RN_676_0 VDD VSS INVD1
XFE_RC_1208_0 n382 n3597 FE_RN_675_0 VDD VSS CKND2D3
XFE_OCPC1212_n87 n87 FE_OCPN3463_n87 VDD VSS CKBD4
XFE_RC_1206_0 n623 FE_RN_495_0 FE_RN_543_0 FE_RN_544_0 VDD VSS OAI21D4
XFE_RC_1205_0 FE_OCPN3445_n1631 FE_RN_673_0 VDD VSS CKND2
XFE_RC_1204_0 n2790 FE_RN_673_0 FE_RN_674_0 VDD VSS IND2D2
XFE_RC_1203_0 n2710 n326 FE_RN_674_0 n877 VDD VSS OAI21D4
XFE_RC_1202_0 n139 FE_OFN1337_n1794 n1221 FE_RN_42 VDD VSS AOI21D4
XFE_RC_1201_0 n1838 n1840 FE_OFN3419_n3224 n1837 VDD VSS AOI21D4
XFE_RC_1200_0 n308 n774 FE_RN_672_0 VDD VSS NR2XD3
XFE_RC_1199_0 n2895 FE_RN_672_0 n199 VDD VSS INR2XD2
XFE_RC_1195_0 FE_OFN3484_n296 n1476 FE_RN_668_0 VDD VSS IND2D1
XFE_RC_1194_0 FE_OFN3484_n296 FE_RN_669_0 VDD VSS CKND1
XFE_RC_1193_0 FE_RN_669_0 n2408 FE_RN_670_0 VDD VSS IND2D1
XFE_RC_1192_0 FE_RN_670_0 FE_RN_668_0 n2414 VDD VSS ND2D2
XFE_RC_1189_0 n2427 FE_RN_665_0 VDD VSS INVD2
XFE_RC_1188_0 n2426 FE_RN_666_0 VDD VSS INVD1
XFE_RC_1173_0 n1844 n2731 n2195 n847 VDD VSS ND3D3
XU1042_dup n563 n561 FE_RN_62 VDD VSS ND2D4
XFE_OCPC1324_FE_OFN74_n2653 FE_OFN74_n2653 FE_OCPN1324_FE_OFN74_n2653 VDD VSS
+ BUFFD2
XFE_RC_1172_0 FE_RN_388_0 FE_RN_657_0 VDD VSS CKND4
XFE_RC_1171_0 FE_RN_657_0 FE_RN_448_0 n2318 VDD VSS NR2XD3
XFE_RC_1169_0 n2738 n132 n222 VDD VSS IND2D4
XFE_RC_1168_0 n518 FE_RN_619_0 FE_RN_656_0 VDD VSS NR2XD3
XFE_RC_1167_0 FE_RN_656_0 FE_RN_618_0 n1816 VDD VSS IND2D4
XFE_RC_1166_0 n1203 FE_RN_604_0 FE_RN_603_0 n1202 VDD VSS OAI21D4
XFE_RC_1160_0 n729 n377 n764 n2712 VDD VSS ND3D8
XFE_RC_1159_0 n81 FE_OCPN1537_n1339 FE_RN_651_0 VDD VSS CKND2D3
XFE_RC_1158_0 n81 n1339 FE_RN_651_0 n746 VDD VSS OAI21D4
XFE_RC_1157_0 n1286 n1215 n1856 FE_RN_581_0 VDD VSS ND3D3
XFE_RC_1156_0 FE_OFN2807_shared_plane_28 n3741 FE_RN_650_0 VDD VSS AN2D0
XFE_RC_1155_0 FE_RN_650_0 n3838 mantissa_value[28] VDD VSS IND2D4
XFE_RC_1153_0 n3034 FE_RN_648_0 VDD VSS CKND2
XFE_RC_1152_0 n3031 FE_RN_648_0 FE_RN_649_0 VDD VSS IND2D2
XFE_RC_1151_0 n480 n481 FE_RN_649_0 n463 VDD VSS OAI21D4
XFE_RC_1150_0 n1883 n2013 n2286 n2941 VDD VSS ND3D8
XFE_RC_1149_0 FE_OFN3496_n261 FE_RN_645_0 VDD VSS CKND2
XFE_RC_1148_0 n2826 FE_RN_645_0 FE_RN_646_0 VDD VSS ND2D4
XFE_RC_1147_0 FE_OFN3496_n261 FE_RN_647_0 VDD VSS CKND2
XFE_RC_1146_0 n2826 FE_RN_647_0 FE_RN_646_0 n1952 VDD VSS OAI21D4
XFE_RC_1141_0 n2516 n2513 VDD VSS CKND4
XFE_RC_1140_0 FE_RN_539_0 n1718 FE_RN_641_0 VDD VSS ND2D2
XFE_RC_1139_0 FE_RN_641_0 n2516 FE_RN_540_0 VDD VSS NR2XD3
XFE_RC_1138_0 n3524 FE_RN_639_0 VDD VSS CKND1
XFE_RC_1137_0 n3389 FE_RN_640_0 VDD VSS INVD2
XFE_RC_1136_0 FE_RN_640_0 n3524 n3389 FE_RN_639_0 n3390 VDD VSS OAI22D2
XFE_OCPC1320_n2206 n2206 FE_OCPN1320_n2206 VDD VSS CKBD1
XFE_RC_1130_0 n797 n2421 n85 FE_OFN2738_x_10 n2854 VDD VSS AOI22D4
XFE_RC_1126_0 n2329 FE_RN_631_0 VDD VSS CKND2
XFE_RC_1125_0 n3472 FE_RN_631_0 FE_RN_632_0 VDD VSS ND2D2
XFE_RC_1124_0 n2329 FE_RN_633_0 VDD VSS CKND1
XFE_RC_1123_0 n3472 FE_RN_633_0 FE_RN_632_0 n3473 VDD VSS OAI21D2
XFE_RC_1122_0 FE_RN_10 FE_RN_263_0 FE_OCPN1553_n2980 n1365 VDD VSS OAI21D4
XFE_OCPC1211_n1646 n1646 FE_OCPN3462_n1646 VDD VSS CKBD4
XFE_RC_1120_0 n1633 n1708 FE_RN_629_0 VDD VSS IND2D2
XFE_RC_1119_0 n1708 n1633 FE_RN_630_0 VDD VSS IND2D2
XFE_RC_1118_0 FE_RN_630_0 FE_RN_629_0 n2670 VDD VSS CKND2D4
XFE_RC_1117_0 n3779 n3832 FE_RN_628_0 VDD VSS ND2D2
XFE_RC_1116_0 FE_RN_628_0 n3778 base_plane[22] VDD VSS ND2D3
XFE_RC_1114_0 n2876 n2255 n2254 n2099 VDD VSS ND3D3
XFE_RC_1111_0 n3539 n112 FE_RN_627_0 VDD VSS ND2D2
XFE_RC_1110_0 FE_RN_627_0 n3538 base_plane[1] VDD VSS CKND2D2
XFE_RC_1106_0 FE_RN_276_0 FE_RN_621_0 VDD VSS INVD1
XFE_RC_1105_0 n1684 FE_RN_622_0 VDD VSS INVD1
XFE_RC_1104_0 n2401 FE_RN_622_0 FE_RN_623_0 VDD VSS IND2D2
XFE_RC_1103_0 n1684 n2401 FE_RN_624_0 VDD VSS ND2D1
XFE_RC_1102_0 FE_RN_624_0 FE_RN_623_0 FE_RN_621_0 FE_RN_602_0 VDD VSS AOI21D4
XFE_RC_1101_0 FE_RN_549_0 FE_RN_465_0 n18 FE_RN_548_0 n520 VDD VSS OAI22D4
XFE_RC_1100_0 n73 n1716 n2154 n800 VDD VSS ND3D3
XFE_RC_1098_0 n1091 n1087 FE_RN_620_0 VDD VSS ND2D2
XFE_RC_1097_0 FE_RN_620_0 n1092 n218 VDD VSS NR2D2
XFE_RC_1096_0 n3170 FE_RN_617_0 VDD VSS CKND2
XFE_RC_1095_0 n518 FE_RN_617_0 FE_RN_618_0 VDD VSS ND2D2
XFE_RC_1094_0 n3170 FE_RN_619_0 VDD VSS CKND2
XFE_RC_173_0_dup n2671 n2089 n2088 FE_RN_60 VDD VSS OAI21D4
XFE_RC_1089_0 n3010 FE_RN_614_0 VDD VSS CKND1
XFE_RC_1088_0 FE_RN_614_0 n1526 FE_RN_615_0 VDD VSS INR2XD2
XFE_RC_1087_0 FE_RN_615_0 FE_RN_259_0 n1926 VDD VSS IND2D4
XFE_RC_1082_0 n2928 FE_RN_609_0 VDD VSS INVD1
XFE_RC_1081_0 FE_RN_609_0 n2055 FE_RN_610_0 VDD VSS IND2D4
XFE_RC_1080_0 FE_RN_610_0 n671 n674 VDD VSS CKND2D4
XFE_RC_1079_0 n1613 FE_RN_608_0 VDD VSS CKND2
XFE_RC_1078_0 FE_RN_608_0 n2224 FE_RN_351_0 n2223 VDD VSS OAI21D4
XFE_RC_1077_0 n3516 FE_RN_605_0 VDD VSS CKND2
XFE_RC_1076_0 n1259 FE_RN_605_0 FE_RN_606_0 VDD VSS ND2D2
XFE_RC_1075_0 n3516 FE_RN_607_0 VDD VSS CKND2
XFE_RC_1074_0 n1259 FE_RN_607_0 FE_RN_606_0 n1258 VDD VSS OAI21D4
XFE_RC_1073_0 FE_RN_46 n1203 FE_RN_603_0 VDD VSS IND2D4
XFE_RC_1072_0 FE_RN_46 FE_RN_604_0 VDD VSS INVD2
XFE_RC_48_0_dup n948 FE_OFN3483_n59 FE_RN_29_0 FE_RN_30 VDD VSS OAI21D4
XFE_RC_1069_0 FE_RN_602_0 n2249 n1270 n1206 VDD VSS OAI21D4
XFE_OCPC1319_n1815 n1815 FE_OCPN1319_n1815 VDD VSS CKBD1
XFE_OCPC1318_n3456 n3456 FE_OCPN1318_n3456 VDD VSS BUFFD2
XFE_RC_1063_0 n3809 FE_RN_595_0 VDD VSS CKND1
XFE_RC_1062_0 n497 FE_RN_595_0 FE_RN_596_0 VDD VSS ND2D2
XFE_RC_1061_0 n3809 FE_RN_597_0 VDD VSS CKND1
XFE_RC_1060_0 n497 FE_RN_597_0 FE_RN_596_0 n496 VDD VSS OAI21D2
XFE_RC_1059_0 n3631 n3629 n3632 n782 VDD VSS OAI21D4
XFE_RC_1050_0 n2546 n2547 FE_RN_588_0 VDD VSS ND2D3
XFE_RC_1049_0 n2547 n2546 FE_RN_588_0 n307 n2549 VDD VSS OAI211D4
XFE_RC_1048_0 n1151 FE_RN_586_0 VDD VSS INVD1
XFE_RC_1047_0 n1153 FE_RN_587_0 VDD VSS CKND2
XFE_RC_1046_0 FE_RN_587_0 FE_RN_586_0 n1153 n1151 n111 FE_RN_462_0 VDD VSS
+ OAI221XD4
XFE_RC_1045_0 n3201 n650 FE_RN_584_0 VDD VSS IND2D1
XFE_RC_1044_0 n3201 FE_RN_585_0 VDD VSS CKND1
XFE_RC_1043_0 n650 FE_RN_585_0 FE_RN_584_0 n3209 VDD VSS OAI21D2
XFE_OCPC1317_FE_OFN2808_shared_plane_22 FE_OCPN1331_FE_OFN2808_shared_plane_22
+ FE_OCPN1317_FE_OFN2808_shared_plane_22 VDD VSS CKBD0
XFE_RC_1037_0 FE_RN_581_0 n1290 n1287 n2020 VDD VSS ND3D3
XFE_RC_1036_0 FE_RN_457_0 FE_RN_458_0 n3678 n3866 VDD VSS AOI21D4
XFE_RC_1035_0 n78 n2001 FE_RN_580_0 VDD VSS IND2D4
XFE_RC_1034_0 FE_RN_580_0 n1862 n330 VDD VSS ND2D3
XFE_RC_1029_0 n1226 FE_RN_574_0 VDD VSS CKND2
XFE_RC_1028_0 FE_RN_577_0 FE_RN_574_0 FE_RN_575_0 VDD VSS ND2D2
XFE_RC_1027_0 n1226 FE_RN_576_0 VDD VSS INVD1
XFE_RC_1026_0 n1112 n1111 FE_RN_577_0 VDD VSS ND2D3
XFE_RC_1025_0 FE_RN_577_0 FE_RN_576_0 FE_RN_575_0 n1438 VDD VSS OAI21D4
XFE_OCPC1210_FE_OFN16_x_12 x_mantissa[12] FE_OCPN3461_FE_OFN16_x_12 VDD VSS
+ CKBD4
XFE_RC_1024_0 n479 n478 n229 n3031 n464 VDD VSS AOI22D4
XFE_RC_1023_0 n46 FE_RN_573_0 VDD VSS CKND2
XFE_RC_1022_0 n2868 n46 n2803 FE_RN_573_0 n2872 VDD VSS AOI22D4
XFE_RC_1015_0 n485 FE_RN_567_0 VDD VSS CKND1
XFE_RC_1014_0 n487 FE_RN_567_0 FE_RN_568_0 VDD VSS CKND2D2
XFE_RC_1013_0 n485 FE_RN_569_0 VDD VSS CKND1
XFE_RC_1012_0 n487 FE_RN_569_0 FE_RN_568_0 n996 VDD VSS OAI21D2
XFE_RC_1011_0 FE_OCPN1193_n2839 n2272 n2274 n2853 n2271 VDD VSS AOI22D4
XFE_OCPC1208_n3557 n3557 FE_OCPN3459_n3557 VDD VSS CKBD1
XFE_RC_1009_0 n2564 n1227 FE_RN_564_0 VDD VSS ND2D1
XFE_RC_1008_0 n1227 FE_RN_565_0 VDD VSS INVD1
XFE_RC_1007_0 n2564 FE_RN_565_0 FE_RN_566_0 VDD VSS IND2D2
XFE_RC_1006_0 FE_RN_566_0 n294 FE_RN_564_0 n2566 VDD VSS ND3D3
XFE_RC_1001_0 FE_RN_9 FE_OCPN1557_n2966 FE_OCPN1432_n883 n76 VDD VSS OAI21D4
XFE_RC_1000_0 n355 n358 n357 n1928 VDD VSS ND3D4
XFE_RC_999_0 n3241 n3235 n258 n1974 n1973 VDD VSS AOI31D4
XFE_RC_998_0 n38 FE_RN_559_0 VDD VSS CKND1
XFE_RC_997_0 n427 FE_RN_559_0 FE_RN_560_0 VDD VSS ND2D2
XFE_RC_996_0 n38 FE_RN_561_0 VDD VSS CKND1
XFE_RC_995_0 n427 FE_RN_561_0 FE_RN_560_0 n37 VDD VSS OAI21D2
XFE_RC_994_0 n53 FE_RN_556_0 VDD VSS CKND2
XFE_RC_993_0 n3051 FE_RN_556_0 FE_RN_557_0 VDD VSS ND2D2
XFE_RC_992_0 n53 FE_RN_558_0 VDD VSS CKND2
XFE_RC_991_0 n3051 FE_RN_558_0 FE_RN_557_0 n2102 VDD VSS OAI21D4
XFE_RC_989_0 FE_PSN1634_n2840 n93 n597 n2862 VDD VSS AOI21D4
XFE_RC_988_0 FE_RN_41_0 divided_plane[24] FE_RN_42_0 VDD VSS IND2D4
XFE_RC_987_0 FE_OFN3478_FE_OFN3423_n1728 n1679 FE_RN_554_0 VDD VSS IND2D1
XFE_RC_986_0 divided_plane[18] FE_OFN3478_FE_OFN3423_n1728 FE_RN_555_0 VDD VSS
+ ND2D2
XFE_RC_985_0 FE_RN_555_0 FE_RN_554_0 mantissa_value[18] VDD VSS ND2D8
XFE_RC_982_0 n3687 n3567 n3568 n1799 VDD VSS OA21D4
XFE_RC_976_0 n2592 n296 FE_RN_551_0 VDD VSS OR2XD1
XFE_RC_975_0 n1233 n2537 FE_RN_551_0 n2612 VDD VSS OAI21D4
XFE_RC_974_0 FE_RN_550_0 n219 VDD VSS CKND2
XFE_RC_973_0 n2836 n2835 n2048 FE_RN_550_0 VDD VSS OAI21D2
XFE_RC_972_0 FE_RN_463_0 FE_RN_548_0 VDD VSS INVD1
XFE_RC_971_0 n18 FE_RN_549_0 VDD VSS INVD2
XFE_RC_967_0 n2932 n2942 FE_RN_546_0 VDD VSS ND2D2
XFE_RC_966_0 n2932 n2942 FE_RN_546_0 n2944 VDD VSS OAI21D2
XFE_RC_965_0 FE_RN_127_0 n2080 n320 FE_RN_545_0 VDD VSS OAI21D2
XFE_RC_964_0 FE_RN_126_0 FE_RN_545_0 n2345 VDD VSS INR2XD2
XFE_RC_963_0 n3619 FE_RN_543_0 VDD VSS INVD1
XFE_RC_961_0 FE_RN_494_0 FE_RN_544_0 n3863 VDD VSS INR2D4
XFE_RC_960_0 n3256 FE_RN_542_0 VDD VSS CKND2
XFE_RC_959_0 n3255 n3256 n3277 FE_RN_542_0 n3281 VDD VSS AOI22D4
XU623_dup FE_OCPN3519_n3128 FE_RN_59 VDD VSS INVD12
XU1171_dup n2436 n1854 n1502 FE_RN_58 VDD VSS AOI21D4
XFE_RC_956_0 n2518 FE_RN_538_0 VDD VSS CKND1
XFE_RC_955_0 n1279 FE_RN_539_0 VDD VSS CKND2
XFE_RC_953_0 FE_RN_540_0 FE_RN_538_0 FE_RN_541_0 VDD VSS NR2D2
XFE_RC_952_0 FE_RN_541_0 n1400 n2527 VDD VSS CKND2D3
XFE_RC_947_0 FE_OCPN1192_n1640 FE_RN_532_0 VDD VSS CKND2
XFE_RC_946_0 FE_RN_532_0 n1223 FE_RN_533_0 VDD VSS ND2D2
XFE_RC_945_0 FE_OCPN1192_n1640 FE_RN_534_0 VDD VSS CKND2
XFE_RC_944_0 n1223 FE_RN_534_0 FE_RN_533_0 n829 VDD VSS OAI21D2
XFE_RC_943_0 n3736 FE_RN_529_0 VDD VSS INVD2
XFE_RC_942_0 n1661 FE_RN_529_0 FE_RN_530_0 VDD VSS ND2D2
XFE_RC_941_0 n3736 FE_RN_531_0 VDD VSS CKND2
XFE_RC_940_0 n1661 FE_RN_531_0 FE_RN_530_0 n3742 VDD VSS OAI21D2
XU2214_dup n3531 n2267 FE_RN_56 VDD VSS ND2D8
XU2382_dup n151 FE_RN_55 VDD VSS INVD6
XFE_RC_934_0 n3239 FE_RN_522_0 VDD VSS CKND2
XFE_RC_933_0 FE_RN_89 FE_RN_522_0 FE_RN_523_0 VDD VSS CKND2D4
XFE_RC_932_0 FE_OFN3486_n3239 FE_RN_524_0 VDD VSS CKND2
XFE_RC_931_0 FE_RN_68 FE_RN_524_0 FE_RN_523_0 n2804 VDD VSS OAI21D4
XFE_RC_930_0 n1561 n3216 FE_RN_520_0 VDD VSS CKND2D4
XFE_RC_929_0 n2306 FE_RN_521_0 VDD VSS CKND2
XFE_RC_928_0 n1561 FE_RN_521_0 FE_RN_520_0 FE_RN_321_0 VDD VSS OAI21D4
XFE_RC_927_0 FE_OCPN1589_FE_RN_117 FE_RN_517_0 VDD VSS CKND4
XFE_RC_926_0 FE_OCPN1470_n1794 FE_RN_517_0 FE_RN_518_0 VDD VSS CKND2D3
XFE_RC_925_0 FE_RN_117 FE_RN_519_0 VDD VSS CKND2
XFE_RC_924_0 FE_PSN1624_n1794 FE_RN_519_0 FE_RN_518_0 FE_RN_38 VDD VSS OAI21D4
XFE_OCPC1207_n3475 n3475 FE_OCPN3458_n3475 VDD VSS CKBD1
XFE_RC_923_0 FE_RN_81_0 FE_RN_515_0 VDD VSS INVD1
XFE_RC_922_0 FE_RN_515_0 n2188 FE_RN_516_0 VDD VSS IND2D4
XFE_RC_921_0 FE_RN_83_0 n2188 FE_RN_516_0 n1843 VDD VSS OAI21D4
XFE_RC_908_0 n2737 FE_RN_504_0 VDD VSS CKND2
XFE_RC_907_0 FE_RN_504_0 n694 n697 n693 VDD VSS IND3D2
XFE_RC_906_0 n348 n809 n808 n347 VDD VSS ND3D8
XFE_RC_905_0 n1328 FE_RN_80_0 FE_RN_499_0 FE_RN_500_0 VDD VSS OAI21D4
XFE_RC_904_0 FE_OFN1370_n1924 FE_OFN1359_n323 FE_RN_503_0 VDD VSS ND2D4
XFE_RC_903_0 FE_OFN1370_n1924 FE_OFN1359_n323 FE_RN_503_0 n1143 VDD VSS OAI21D4
XFE_RC_902_0 n3741 FE_RN_502_0 VDD VSS CKND2
XFE_RC_901_0 FE_RN_502_0 n1418 n1419 n405 VDD VSS IND3D4
XFE_RC_900_0 n3476 FE_RN_501_0 VDD VSS INVD1
XU3538_dup1 n1965 FE_OFN1383_n2906 FE_OCPN1484_n1964 FE_RN_53 VDD VSS AOI21D4
XFE_RC_34_0_dup FE_RN_13 n2456 n2458 FE_RN_29 VDD VSS ND3D8
XFE_OCPC1315_n3660 n3660 FE_OCPN1315_n3660 VDD VSS CKBD1
XFE_RC_898_0 n1842 FE_RN_499_0 VDD VSS INVD1
XFE_RC_896_0 FE_RN_79_0 FE_RN_500_0 n1580 VDD VSS INR2D4
XFE_RC_895_0 n2019 n917 FE_RN_496_0 VDD VSS NR2D4
XFE_RC_894_0 n419 n2123 FE_RN_497_0 VDD VSS ND2D4
XFE_RC_893_0 FE_RN_497_0 FE_RN_496_0 FE_RN_498_0 VDD VSS NR2XD4
XFE_RC_892_0 FE_RN_498_0 n969 n971 VDD VSS CKND2D8
XFE_RC_891_0 n2330 FE_RN_493_0 VDD VSS CKND1
XFE_RC_890_0 n623 FE_RN_493_0 FE_RN_494_0 VDD VSS ND2D2
XFE_RC_889_0 n2330 FE_RN_495_0 VDD VSS CKND2
XFE_RC_887_0 FE_OCPN1152_n2967 n2968 FE_RN_491_0 VDD VSS IND2D2
XFE_RC_886_0 n2968 FE_OCPN1152_n2967 FE_RN_492_0 VDD VSS IND2D4
XFE_RC_885_0 FE_RN_492_0 FE_RN_491_0 shared_plane[4] VDD VSS CKND2D8
XFE_RC_884_0 n445 n1906 FE_RN_174_0 n350 VDD VSS ND3D8
XFE_RC_883_0 n2722 n258 FE_RN_490_0 VDD VSS NR2D2
XFE_RC_882_0 FE_RN_490_0 FE_RN_50 n1445 VDD VSS IND2D2
XFE_RC_881_0 n3388 FE_RN_487_0 VDD VSS INVD2
XFE_RC_880_0 FE_RN_94 FE_RN_487_0 FE_RN_488_0 VDD VSS ND2D4
XFE_RC_879_0 n3388 FE_RN_489_0 VDD VSS CKND2
XFE_RC_878_0 n2065 FE_RN_489_0 FE_RN_488_0 shared_plane[12] VDD VSS OAI21D4
XFE_RC_877_0 n3658 FE_RN_485_0 VDD VSS INVD1
XFE_RC_876_0 n3614 n1167 FE_RN_485_0 FE_RN_486_0 VDD VSS OAI21D2
XFE_RC_875_0 FE_RN_110_0 FE_RN_486_0 n3862 VDD VSS INR2D4
XFE_OCPC1206_x_5 FE_OCPN1227_FE_OFN22_x_5 FE_OCPN3457_x_5 VDD VSS INVD4
XFE_OCPC1205_x_5 x_mantissa[5] FE_OCPN1227_FE_OFN22_x_5 VDD VSS CKND8
XFE_OCPC1204_x_5 x_mantissa[5] n960 VDD VSS INVD4
XFE_OCPC1203_x_5 x_mantissa[5] n1631 VDD VSS CKND8
XFE_RC_870_0 n2942 FE_RN_481_0 VDD VSS CKND1
XFE_RC_869_0 n439 FE_RN_482_0 VDD VSS CKND4
XFE_RC_868_0 FE_RN_482_0 n2942 n439 FE_RN_481_0 n438 VDD VSS OAI22D4
XFE_RC_863_0 FE_RN_92 n885 FE_RN_477_0 VDD VSS CKND2D2
XFE_RC_862_0 FE_RN_92 n885 FE_RN_477_0 n1257 VDD VSS OAI21D2
XFE_OCPC1201_FE_RN_41 FE_RN_41 FE_OCPN3456_FE_RN_41 VDD VSS BUFFD3
XFE_RC_857_0 n637 n214 n636 n1247 VDD VSS OAI21D4
XFE_RC_856_0 n1774 n3546 n3549 n1418 VDD VSS ND3D3
XFE_RC_855_0 n2739 n2738 n3071 FE_RN_19 VDD VSS OAI21D4
XFE_RC_854_0 FE_RN_102 FE_RN_473_0 VDD VSS CKND4
XFE_RC_853_0 FE_OFN1337_n1794 FE_RN_473_0 FE_RN_474_0 VDD VSS ND2D3
XFE_RC_852_0 FE_RN_102 FE_RN_475_0 VDD VSS INVD4
XFE_RC_851_0 FE_OFN1337_n1794 FE_RN_475_0 FE_RN_474_0 n2562 VDD VSS OAI21D4
XFE_RC_849_0 FE_RN_13 FE_OFN2777_n2457 FE_OFN1334_n2456 FE_RN_446_0 n192 VDD
+ VSS AOI31D4
XFE_RC_848_0 n739 FE_RN_470_0 VDD VSS CKND1
XFE_RC_847_0 FE_OFN1333_n1420 FE_RN_470_0 FE_RN_471_0 VDD VSS ND2D2
XFE_RC_846_0 n739 FE_RN_472_0 VDD VSS CKND1
XFE_RC_845_0 FE_OFN1333_n1420 FE_RN_472_0 FE_RN_471_0 n738 VDD VSS OAI21D2
XU2759_dup n728 n3626 FE_RN_52 VDD VSS NR2XD4
XFE_RC_844_0 n2034 FE_RN_466_0 VDD VSS INVD1
XFE_RC_843_0 n2915 FE_RN_467_0 VDD VSS INVD1
XFE_RC_842_0 FE_RN_467_0 n2144 FE_RN_468_0 VDD VSS IND2D4
XFE_RC_841_0 FE_RN_468_0 FE_RN_466_0 FE_RN_469_0 VDD VSS CKND2D4
XFE_RC_840_0 FE_RN_469_0 n2030 n2173 VDD VSS ND2D8
XFE_RC_838_0 n3755 FE_RN_463_0 VDD VSS CKND1
XFE_RC_836_0 n3755 FE_RN_465_0 VDD VSS CKND1
XFE_RC_834_0 n529 n528 n531 n527 VDD VSS ND3D3
XFE_RC_546_0_dup1 FE_OFN100_n2899 FE_RN_302_0 FE_RN_301_0 FE_RN_51 VDD VSS
+ OAI21D4
XFE_RC_831_0 FE_RN_462_0 n2772 base_plane[5] VDD VSS CKND2D8
XFE_OCPC1313_n390 n390 FE_OCPN1313_n390 VDD VSS CKBD4
XU866_dup n148 n958 FE_RN_16 VDD VSS CKND2D8
XFE_RC_830_0 n1256 n152 n1299 VDD VSS IND2D4
XFE_RC_829_0 n843 n2755 n1031 n1523 VDD VSS ND3D8
XFE_RC_828_0 n2107 FE_RN_459_0 VDD VSS CKND2
XFE_RC_827_0 FE_OFN1352_n2899 FE_RN_459_0 FE_RN_460_0 VDD VSS ND2D4
XFE_RC_826_0 n2107 FE_RN_461_0 VDD VSS CKND2
XFE_RC_825_0 FE_OFN1352_n2899 FE_RN_461_0 FE_RN_460_0 n2675 VDD VSS OAI21D4
XFE_RC_823_0 n2307 FE_RN_456_0 VDD VSS INVD2
XFE_RC_822_0 n2964 FE_RN_456_0 FE_RN_457_0 VDD VSS IND2D4
XFE_RC_821_0 n2307 n2964 FE_RN_458_0 VDD VSS CKND2D2
XFE_RC_819_0 n404 n2669 FE_RN_455_0 VDD VSS ND2D3
XFE_RC_818_0 n404 n2669 FE_RN_455_0 n2680 VDD VSS OAI21D4
XFE_RC_817_0 n3756 FE_RN_453_0 VDD VSS INVD1
XFE_OCPC1311_shared_plane_24 FE_OCPN3472_shared_plane_24
+ FE_OCPN1311_shared_plane_24 VDD VSS CKBD0
XFE_RC_811_0 n3590 FE_RN_449_0 VDD VSS CKND2
XFE_RC_810_0 n1450 FE_RN_449_0 FE_RN_450_0 VDD VSS ND2D2
XFE_RC_809_0 n3590 FE_RN_451_0 VDD VSS CKND1
XFE_RC_808_0 n1450 FE_RN_451_0 FE_RN_450_0 n784 VDD VSS OAI21D2
XFE_OCPC1200_n2550 n2550 n3479 VDD VSS INVD2
XFE_RC_806_0 n3528 FE_RN_447_0 VDD VSS INVD1
XFE_RC_805_0 n2312 n1383 FE_RN_447_0 FE_RN_448_0 VDD VSS OAI21D4
XFE_RC_803_0 FE_RN_13 FE_OFN2777_n2457 FE_OFN1334_n2456 n1672 VDD VSS ND3D8
XFE_RC_802_0 n2149 FE_RN_446_0 VDD VSS INVD1
XFE_RC_800_0 n2744 FE_OCPN1294_n2744 VDD VSS BUFFD4
XFE_RC_799_0 FE_OCPN1400_FE_RN_56 FE_RN_441_0 VDD VSS CKND2
XFE_RC_796_0 n1620 FE_RN_444_0 VDD VSS INVD2
XFE_RC_795_0 FE_RN_444_0 n2744 FE_RN_445_0 VDD VSS ND2D2
XFE_RC_793_0 FE_RN_411_0 n1106 FE_RN_440_0 VDD VSS ND2D3
XFE_RC_790_0 FE_RN_23 n1798 n1796 n1795 VDD VSS AOI21D4
XFE_RC_786_0 n1803 FE_RN_437_0 VDD VSS INVD1
XFE_RC_784_0 n3224 FE_RN_439_0 VDD VSS INVD1
XFE_RC_774_0 n2017 FE_RN_429_0 VDD VSS CKND1
XFE_RC_773_0 FE_RN_429_0 n1252 n1253 n687 VDD VSS IND3D4
XFE_RC_772_0 n1821 n1742 FE_RN_428_0 VDD VSS IND2D2
XFE_RC_771_0 FE_RN_428_0 FE_OFN105_n1078 n1500 VDD VSS IND2D4
XFE_RC_770_0 FE_RN_427_0 n3339 VDD VSS INVD6
XFE_RC_769_0 n949 n3543 n3348 FE_RN_427_0 VDD VSS OAI21D4
XFE_RC_768_0 n753 FE_RN_103 FE_RN_425_0 VDD VSS NR2D3
XFE_RC_767_0 n722 FE_RN_426_0 VDD VSS CKND2
XFE_RC_766_0 FE_RN_426_0 FE_RN_425_0 n723 VDD VSS NR2D2
XFE_RC_764_0 n523 FE_RN_422_0 VDD VSS CKND2
XFE_RC_763_0 n365 FE_RN_422_0 FE_RN_423_0 VDD VSS ND2D4
XFE_RC_762_0 n523 FE_RN_424_0 VDD VSS CKND1
XFE_RC_756_0 FE_RN_38_0 divided_plane[23] FE_RN_419_0 VDD VSS IND2D4
XFE_RC_755_0 FE_RN_419_0 n2891 mantissa_value[23] VDD VSS ND2D8
XFE_RC_754_0 n3398 FE_RN_417_0 VDD VSS INVD1
XFE_RC_753_0 FE_RN_417_0 divided_plane[26] FE_RN_418_0 VDD VSS IND2D4
XFE_RC_752_0 FE_RN_418_0 n2389 mantissa_value[26] VDD VSS CKND2D8
XFE_RC_750_0 n2552 n3479 FE_RN_415_0 VDD VSS IND2D2
XFE_RC_749_0 n3479 n2552 FE_RN_416_0 VDD VSS IND2D2
XFE_RC_748_0 FE_RN_416_0 FE_RN_415_0 shared_plane[13] VDD VSS CKND2D4
XFE_RC_746_0 n21 FE_RN_414_0 VDD VSS CKND2
XFE_RC_744_0 n3522 FE_RN_413_0 VDD VSS INVD1
XFE_RC_742_0 n2236 FE_RN_28 FE_RN_412_0 VDD VSS IND2D2
XFE_RC_741_0 FE_RN_412_0 FE_RN_411_0 VDD VSS INVD4
XFE_RC_735_0 FE_RN_215_0 divided_plane[27] FE_RN_409_0 VDD VSS IND2D4
XFE_RC_734_0 FE_RN_409_0 n3326 mantissa_value[27] VDD VSS ND2D8
XU782_dup FE_OFN1362_n766 FE_OFN3487_n3408 FE_RN_50 VDD VSS ND2D8
XFE_RC_731_0 n540 FE_RN_405_0 VDD VSS INVD2
XFE_RC_730_0 FE_RN_405_0 n744 n708 VDD VSS IND2D4
XFE_RC_729_0 n540 FE_RN_406_0 VDD VSS INVD1
XFE_RC_728_0 FE_RN_406_0 n744 FE_RN_407_0 VDD VSS IND2D4
XFE_RC_727_0 FE_RN_407_0 FE_RN_144 n148 VDD VSS ND2D8
XFE_RC_726_0 n3742 n111 FE_RN_403_0 VDD VSS ND2D2
XFE_RC_721_0 n3694 FE_RN_401_0 VDD VSS CKND2
XFE_RC_720_0 FE_RN_401_0 n3693 n1455 VDD VSS CKND2D2
XFE_RC_718_0 n1613 FE_OCPN1219_n2342 n129 n1325 VDD VSS AOI21D4
XFE_RC_717_0 n2186 n699 FE_RN_398_0 VDD VSS ND2D4
XFE_RC_716_0 n2186 n2187 FE_RN_399_0 VDD VSS ND2D3
XFE_RC_715_0 FE_RN_399_0 FE_RN_398_0 FE_RN_400_0 VDD VSS ND2D4
XFE_RC_714_0 n2436 FE_RN_400_0 n860 VDD VSS ND2D8
XFE_RC_710_0 n789 n2564 FE_RN_396_0 VDD VSS ND2D2
XFE_RC_709_0 n789 n2564 FE_RN_396_0 n2567 VDD VSS OAI21D2
XFE_RC_708_0 FE_RN_96 n3650 FE_RN_395_0 VDD VSS ND2D2
XFE_RC_707_0 FE_OCPN1394_n727 n3650 FE_RN_395_0 n1360 VDD VSS OAI21D4
XFE_RC_706_0 n83 n3746 FE_RN_394_0 VDD VSS ND2D2
XFE_RC_705_0 n83 n3746 FE_RN_394_0 n3749 VDD VSS OAI21D2
XFE_OCPC1305_n1620 n1620 FE_OCPN1305_n1620 VDD VSS BUFFD4
XFE_RC_699_0 n954 n952 n953 n565 VDD VSS ND3D8
XFE_RC_696_0 n1383 n2312 FE_RN_388_0 VDD VSS CKND2D4
XFE_RC_694_0 n3663 n2007 n2174 n624 VDD VSS AOI21D4
XFE_OCPC1195_shared_plane_12 FE_OCPN3454_shared_plane_12
+ FE_OCPN3455_shared_plane_12 VDD VSS INVD4
XFE_OCPC1194_shared_plane_12 shared_plane[12] FE_OCPN3454_shared_plane_12 VDD
+ VSS INVD8
XFE_RC_693_0 n2903 FE_RN_385_0 VDD VSS CKND1
XFE_RC_691_0 n2903 FE_RN_387_0 VDD VSS CKND1
XFE_RC_689_0 n3328 n675 n1016 n560 VDD VSS ND3D4
XU2355_dup n1567 FE_OCPN3508_y_2 FE_RN_49 VDD VSS CKND2D8
XFE_RC_686_0 FE_RN_8 n601 n308 n404 VDD VSS OAI21D4
XFE_RC_685_0 n140 FE_RN_381_0 VDD VSS CKND4
XFE_RC_684_0 n1517 FE_RN_381_0 FE_RN_382_0 VDD VSS CKND2D4
XFE_RC_683_0 n140 FE_RN_383_0 VDD VSS INVD4
XFE_RC_682_0 n1517 FE_RN_383_0 FE_RN_382_0 n1516 VDD VSS OAI21D4
XU2953_dup n3521 n864 n3520 FE_RN_47 VDD VSS AOI21D4
XU2937_dup n1826 n851 n3583 FE_RN_46 VDD VSS OAI21D4
XFE_RC_677_0 n3689 FE_RN_377_0 VDD VSS CKND2
XFE_RC_676_0 n2947 FE_RN_378_0 VDD VSS CKND2
XFE_RC_675_0 n152 FE_RN_378_0 FE_RN_377_0 n3694 VDD VSS AOI21D4
XFE_RC_674_0 n2937 n2936 n1751 n2067 n3330 VDD VSS OAI22D4
XFE_OCPC1302_n917 n917 FE_OCPN1302_n917 VDD VSS BUFFD2
XFE_OCPC1188_n2296 n2278 FE_OCPN1296_n2751 VDD VSS INVD6
XFE_OCPC1187_n2296 n765 n2278 VDD VSS INVD8
XFE_OCPC1186_n2296 n765 n2751 VDD VSS INVD2
XFE_OCPC1185_n2296 n765 FE_OFN2721_n2296 VDD VSS INVD4
XFE_OCPC1184_n2296 n60 n765 VDD VSS INVD8
XFE_OCPC1183_n2296 n2296 n60 VDD VSS INVD6
XFE_OCPC1301_shared_plane_26 shared_plane[26] FE_OCPN1301_shared_plane_26 VDD
+ VSS CKBD0
XU3265_dup csa_sum_1[10] csa_carry_1[10] FE_RN_44 VDD VSS NR2XD4
XFE_RC_653_0 n1070 n1349 FE_RN_97 n1347 VDD VSS AOI21D4
XFE_RC_637_0 n3671 FE_RN_353_0 VDD VSS CKND1
XFE_RC_636_0 n1070 FE_RN_353_0 FE_RN_354_0 VDD VSS ND2D2
XFE_RC_635_0 n3671 FE_RN_355_0 VDD VSS CKND1
XFE_RC_634_0 n1070 FE_RN_355_0 FE_RN_354_0 n1623 VDD VSS OAI21D2
XFE_RC_633_0 FE_RN_112 n1034 FE_RN_352_0 VDD VSS CKND2D4
XFE_RC_632_0 n1035 n1034 FE_RN_352_0 n922 VDD VSS OAI21D4
XFE_RC_630_0 n1613 n2224 FE_RN_351_0 VDD VSS IND2D4
XFE_RC_626_0 n3479 FE_OCPN1483_n2049 FE_OCPN1226_n1359 n3483 VDD VSS OAI21D4
XFE_RC_616_0 FE_RN_33 n3669 n2737 n1295 VDD VSS OAI21D4
XFE_RC_598_0 FE_OCPN3508_y_2 n74 n1567 n338 VDD VSS ND3D8
XFE_RC_597_0 n2889 FE_RN_328_0 VDD VSS CKND2
XFE_RC_596_0 FE_RN_328_0 n1525 FE_RN_329_0 VDD VSS IND2D4
XFE_RC_595_0 FE_RN_329_0 n1614 n178 VDD VSS ND2D8
XFE_RC_593_0 FE_RN_72 n2284 n2068 FE_RN_15 VDD VSS AOI21D4
XFE_RC_588_0 FE_RN_309_0 FE_RN_311_0 FE_RN_308_0 n2347 VDD VSS AOI21D4
XFE_RC_583_0 FE_OFN3502_n2719 FE_OCPN3510_y_2 FE_RN_324_0 VDD VSS CKND2D4
XFE_RC_581_0 FE_OFN3502_n2719 FE_OCPN3510_y_2 FE_RN_324_0 n413 VDD VSS OAI21D4
XU2566_dup n941 FE_RN_82 FE_RN_43 VDD VSS ND2D8
XFE_OCPC1292_n3360 n3360 FE_OCPN1292_n3360 VDD VSS CKBD0
XFE_OCPC1291_n2785 n2785 FE_OCPN1291_n2785 VDD VSS BUFFD4
XU817_dup FE_OCPN3518_n3128 FE_RN_41 VDD VSS CKND16
XFE_OCPC1290_n1150 FE_OCPN1423_n1150 FE_OCPN1290_n1150 VDD VSS BUFFD4
XU1987_dup n1025 n1024 FE_RN_40 VDD VSS CKND2D4
XFE_OCPC1289_n350 n350 FE_OCPN1289_n350 VDD VSS BUFFD4
XFE_OCPC1287_shared_plane_20 FE_OCPN1507_shared_plane_20
+ FE_OCPN1287_shared_plane_20 VDD VSS CKBD0
XFE_OCPC1286_n3490 n3490 FE_OCPN1286_n3490 VDD VSS BUFFD4
XFE_OCPC1285_shared_plane_28 shared_plane[28] FE_OCPN1285_shared_plane_28 VDD
+ VSS CKBD0
XFE_OCPC1174_FE_RN_21 FE_RN_21 n114 VDD VSS BUFFD8
XU2610_dup n542 FE_RN_37 VDD VSS INVD4
XFE_OCPC1281_n1150 FE_OCPN1290_n1150 FE_OCPN1281_n1150 VDD VSS CKBD4
XU2178_dup n2199 n889 FE_RN_36 VDD VSS ND2D4
XFE_OCPC1276_n3351 FE_OCPN1397_n3351 FE_OCPN1276_n3351 VDD VSS BUFFD4
XU2817_dup n882 n2464 FE_RN_156 FE_RN_35 VDD VSS AOI21D4
XU2170_dup n2679 n134 FE_RN_34 VDD VSS NR2D3
XU1719_dup n1429 n1427 FE_RN_33 VDD VSS CKND2D2
XU780_dup n398 n2810 FE_RN_32 VDD VSS ND2D4
XFE_OCPC1270_n3387 n3387 FE_OCPN1270_n3387 VDD VSS CKBD1
XU3538_dup FE_RN_115 FE_RN_80 n1964 FE_RN_31 VDD VSS AOI21D4
XFE_OCPC1268_n288 n288 FE_OCPN1268_n288 VDD VSS BUFFD2
XFE_OCPC1267_n864 n864 FE_OCPN1267_n864 VDD VSS BUFFD2
XU1025_dup n1775 n1166 FE_RN_28 VDD VSS CKND2D4
XFE_OCPC1265_n3217 FE_RN_35 FE_OCPN1265_n3217 VDD VSS BUFFD4
XFE_OCPC1264_n1249 n1249 FE_OCPN1264_n1249 VDD VSS BUFFD2
XFE_OCPC1263_n942 n942 FE_OCPN1263_n942 VDD VSS CKBD1
XU1115_dup n1315 n1130 FE_RN_27 VDD VSS ND2D3
XU2267_dup n961 n1018 FE_RN_25 VDD VSS ND2D4
XFE_OCPC1256_n2907 n2907 FE_OCPN1256_n2907 VDD VSS CKBD4
XFE_OCPC1254_n2845 n2845 FE_OCPN1254_n2845 VDD VSS BUFFD4
XU3078_dup FE_PSN1619_n1021 n3384 n3365 FE_RN_24 VDD VSS OAI21D4
XFE_RC_396_0_dup n3690 n3689 n3691 FE_RN_23 VDD VSS OAI21D4
XFE_RC_546_0_dup FE_RN_8 FE_RN_302_0 FE_RN_301_0 FE_RN_21 VDD VSS OAI21D4
XFE_OCPC1251_n3494 n3494 FE_OCPN1251_n3494 VDD VSS BUFFD4
XFE_OCPC1250_shared_plane_24 FE_OCPN1311_shared_plane_24
+ FE_OCPN1250_shared_plane_24 VDD VSS CKBD0
XFE_RC_576_0 FE_RN_321_0 FE_RN_7_0 FE_RN_8_0 VDD VSS ND2D4
XU49_dup n397 n978 FE_RN_20 VDD VSS CKND2D4
XFE_RC_575_0 n3811 FE_RN_315_0 VDD VSS CKND2
XFE_RC_574_0 n840 n3331 FE_RN_316_0 VDD VSS ND2D4
XFE_RC_572_0 n305 FE_RN_318_0 VDD VSS CKND2
XFE_RC_571_0 n868 n234 FE_RN_319_0 VDD VSS ND2D4
XFE_RC_570_0 n234 n868 FE_RN_319_0 FE_RN_318_0 FE_RN_320_0 VDD VSS OAI211D4
XFE_OCPC1247_shared_plane_27 shared_plane[27] FE_OCPN1247_shared_plane_27 VDD
+ VSS CKBD0
XFE_RC_567_0 FE_OCPN1286_n3490 FE_RN_312_0 FE_RN_313_0 VDD VSS INR2D4
XFE_RC_566_0 FE_RN_3 n2370 FE_RN_314_0 VDD VSS ND2D3
XFE_OCPC1245_csa_sum_1_8 csa_sum_1[8] FE_OCPN1245_csa_sum_1_8 VDD VSS CKBD1
XFE_RC_564_0 n3695 FE_RN_308_0 VDD VSS CKND2
XFE_RC_562_0 n2175 FE_RN_310_0 VDD VSS CKND2
XFE_RC_561_0 FE_RN_310_0 n2176 FE_RN_311_0 VDD VSS CKND2D2
XFE_RC_559_0 n2745 FE_RN_306_0 VDD VSS CKND2
XFE_RC_558_0 n536 n547 n918 FE_RN_307_0 VDD VSS ND3D4
XFE_RC_557_0 FE_RN_307_0 FE_RN_306_0 n864 VDD VSS ND2D4
XFE_OCPC1163_x_3 FE_OCPN1495_n1916 FE_OCPN3449_x_3 VDD VSS CKBD1
XFE_OCPC1162_x_3 n263 FE_OCPN1228_n1251 VDD VSS INVD6
XFE_OCPC1161_x_3 n263 n1251 VDD VSS INVD4
XFE_OCPC1160_x_3 FE_OCPN2_x_3 n1916 VDD VSS BUFFD12
XFE_OCPC1159_x_3 FE_OCPN2_x_3 n263 VDD VSS INVD8
XFE_OCPC1157_x_3 x_mantissa[3] n2686 VDD VSS BUFFD4
XFE_OCPC1155_y_4 FE_OCPN1275_n872 n1570 VDD VSS CKBD1
XFE_OCPC1154_y_4 n2075 n2153 VDD VSS CKND2
XU738_dup n1312 n1311 FE_RN_18 VDD VSS ND2D4
XFE_RC_549_0 n2895 n2896 FE_RN_300_0 VDD VSS CKND2D4
XFE_RC_548_0 n2898 n595 FE_RN_300_0 FE_RN_301_0 VDD VSS AOI21D4
XFE_RC_547_0 n2894 n595 FE_RN_302_0 VDD VSS CKND2D4
XFE_RC_546_0 FE_RN_8 FE_RN_302_0 FE_RN_301_0 n115 VDD VSS OAI21D4
XFE_RC_69_0_dup n3376 n1150 n1815 FE_RN_7 VDD VSS OAI21D4
XFE_RC_545_0 n3315 FE_RN_299_0 VDD VSS CKND2
XFE_RC_544_0 n1008 FE_RN_299_0 n1474 n967 VDD VSS OAI21D4
XFE_RC_524_0 n2284 n1477 FE_RN_7 n3367 VDD VSS AOI21D4
XFE_RC_514_0 n48 FE_RN_276_0 VDD VSS INVD1
XFE_RC_511_0 n892 n891 n3628 selected_delta_3[8] VDD VSS AOI21D4
XFE_RC_510_0 n2778 n2540 n2429 n1506 VDD VSS OAI21D4
XFE_RC_509_0 FE_RN_29 n1676 FE_OCPN1481_FE_OFN10_x_21 n1035 VDD VSS OAI21D4
XFE_RC_506_0 n2455 FE_OCPN1582_n2901 FE_RN_274_0 VDD VSS ND2D2
XFE_RC_505_0 n2453 FE_RN_274_0 n2454 VDD VSS CKND2D4
XFE_RC_500_0 n1806 n1804 n1805 n2221 VDD VSS ND3D4
XFE_RC_499_0 n2798 n1384 n2825 n677 VDD VSS OAI21D2
XFE_RC_498_0 n1416 n1413 n1415 n400 VDD VSS ND3D4
XFE_RC_497_0 n1194 n1192 n1191 n2465 VDD VSS ND3D4
XFE_RC_496_0 n3716 FE_RN_269_0 VDD VSS CKND1
XFE_RC_495_0 n1420 FE_RN_269_0 FE_RN_270_0 VDD VSS CKND2D4
XFE_RC_494_0 n3716 FE_RN_271_0 VDD VSS CKND1
XFE_RC_492_0 n2567 n111 FE_RN_268_0 VDD VSS ND2D2
XFE_RC_491_0 FE_RN_268_0 n2566 base_plane[3] VDD VSS CKND2D4
XFE_RC_490_0 n2750 n94 n980 n979 VDD VSS AOI21D4
XFE_RC_489_0 n923 FE_OFN2724_n107 FE_RN_266_0 VDD VSS IND2D2
XFE_RC_488_0 FE_OFN2724_n107 n923 FE_RN_267_0 VDD VSS IND2D4
XFE_RC_487_0 FE_RN_267_0 FE_RN_266_0 n2822 VDD VSS ND2D4
XFE_RC_485_0 n2606 FE_RN_264_0 VDD VSS CKND1
XFE_RC_484_0 n2541 FE_RN_264_0 FE_RN_265_0 VDD VSS IND2D2
XFE_RC_483_0 n2605 FE_RN_265_0 n2634 VDD VSS CKND2D4
XFE_RC_481_0 n1621 FE_RN_263_0 VDD VSS CKND2
XFE_RC_478_0 n1225 FE_RN_81 FE_RN_261_0 VDD VSS CKND2D4
XFE_RC_476_0 n1225 FE_RN_262_0 FE_RN_261_0 n2558 VDD VSS OAI21D4
XFE_RC_475_0 n1526 n3010 FE_RN_259_0 VDD VSS ND2D2
XFE_RC_473_0 n1037 n2250 n1273 n1122 VDD VSS ND3D8
XFE_RC_472_0 n231 n3378 FE_RN_257_0 VDD VSS IND2D4
XFE_RC_471_0 n231 FE_RN_258_0 VDD VSS CKND1
XFE_RC_470_0 n3378 FE_RN_258_0 FE_RN_257_0 shared_plane[6] VDD VSS OAI21D4
XFE_RC_469_0 n3658 FE_RN_255_0 VDD VSS INVD1
XFE_RC_468_0 n32 FE_RN_33_0 FE_RN_255_0 FE_RN_256_0 VDD VSS OAI21D4
XFE_RC_462_0 n3492 FE_RN_249_0 VDD VSS INVD2
XFE_RC_461_0 n3493 FE_RN_249_0 FE_RN_250_0 VDD VSS ND2D3
XFE_RC_460_0 n3492 FE_RN_251_0 VDD VSS INVD2
XFE_RC_459_0 n3493 FE_RN_251_0 FE_RN_250_0 shared_plane[10] VDD VSS OAI21D4
XFE_OCPC1139_n1631 n1631 FE_OCPN3445_n1631 VDD VSS CKBD4
XFE_RC_454_0 FE_RN_247_0 n3546 VDD VSS INVD4
XFE_RC_453_0 n3545 n2146 n1911 FE_RN_247_0 VDD VSS OAI21D4
XFE_RC_452_0 n3229 FE_RN_244_0 VDD VSS CKND1
XFE_RC_451_0 n1536 FE_RN_244_0 FE_RN_245_0 VDD VSS CKND2D2
XFE_RC_450_0 n3229 FE_RN_246_0 VDD VSS CKND1
XFE_RC_449_0 n1536 FE_RN_246_0 FE_RN_245_0 n2180 VDD VSS OAI21D2
XFE_RC_448_0 n3222 n3475 n3223 n2279 VDD VSS OAI21D4
XFE_OCPC1138_n2980 n2980 FE_OCPN3444_n2980 VDD VSS CKBD4
XFE_RC_444_0 n2302 n1325 FE_RN_241_0 VDD VSS IND2D2
XFE_RC_443_0 n1325 FE_RN_242_0 VDD VSS INVD2
XFE_RC_442_0 FE_RN_242_0 n2302 FE_RN_243_0 VDD VSS ND2D2
XFE_RC_441_0 FE_RN_243_0 FE_RN_241_0 n344 VDD VSS ND2D3
XFE_RC_440_0 FE_OFN1354_n2417 FE_RN_238_0 VDD VSS CKND2
XFE_RC_439_0 n122 FE_RN_238_0 FE_RN_239_0 VDD VSS CKND2D4
XFE_RC_438_0 FE_OFN1354_n2417 FE_RN_240_0 VDD VSS CKND2
XFE_RC_437_0 n122 FE_RN_240_0 FE_RN_239_0 n1327 VDD VSS OAI21D4
XFE_RC_434_0 n1839 n1840 n1837 n1836 VDD VSS OAI21D4
XFE_OCPC1137_n58 n58 FE_OCPN3443_n58 VDD VSS CKBD1
XFE_RC_425_0 n1874 n3339 n3342 n1872 n1871 VDD VSS OAI211D4
XFE_RC_424_0 n3738 n3737 FE_RN_229_0 VDD VSS IND2D2
XFE_RC_423_0 n3737 FE_RN_230_0 VDD VSS CKND2
XFE_RC_422_0 FE_RN_230_0 n3738 FE_RN_231_0 VDD VSS ND2D2
XFE_RC_421_0 FE_RN_231_0 FE_RN_229_0 n3739 VDD VSS CKND2D2
XFE_RC_419_0 FE_RN_30 n2703 FE_RN_227_0 VDD VSS IND2D2
XFE_RC_418_0 n2703 n2702 FE_RN_228_0 VDD VSS IND2D2
XFE_RC_417_0 FE_RN_228_0 FE_RN_227_0 n2195 VDD VSS CKND2D4
XFE_RC_416_0 FE_OFN3488_n3837 FE_RN_226_0 VDD VSS CKND1
XFE_RC_415_0 divided_plane[19] n3837 n177 FE_RN_226_0 mantissa_value[19] VDD
+ VSS AO22D4
XFE_OCPC1136_n2435 n2435 FE_OCPN3442_n2435 VDD VSS BUFFD4
XFE_RC_414_0 n2325 FE_RN_223_0 VDD VSS CKND1
XFE_RC_413_0 n873 FE_RN_223_0 FE_RN_224_0 VDD VSS CKND2D2
XFE_RC_412_0 n2325 FE_RN_225_0 VDD VSS CKND1
XFE_RC_411_0 n873 FE_RN_225_0 FE_RN_224_0 n339 VDD VSS OAI21D2
XFE_RC_410_0 n356 n3149 n3148 n2045 VDD VSS AOI21D4
XFE_RC_408_0 n3325 FE_RN_220_0 VDD VSS CKND1
XFE_RC_407_0 FE_OFN1333_n1420 FE_RN_220_0 FE_RN_221_0 VDD VSS CKND2D4
XFE_RC_406_0 n3325 FE_RN_222_0 VDD VSS CKND2
XFE_RC_405_0 n1420 FE_RN_222_0 FE_RN_221_0 n1436 VDD VSS OAI21D4
XFE_RC_403_0 FE_OCPN1153_n2688 n2486 n2689 n1642 n2489 VDD VSS OAI22D4
XFE_RC_402_0 n768 n767 n382 VDD VSS ND2D4
XFE_RC_401_0 n768 n767 FE_OFN66_n382 VDD VSS CKND2D8
XFE_RC_396_0 n3690 n3689 n3691 n3598 VDD VSS OAI21D4
XFE_RC_395_0 n3398 FE_RN_215_0 VDD VSS INVD1
XFE_OCPC1237_shared_plane_25 FE_OCPN3470_shared_plane_25
+ FE_OCPN1237_shared_plane_25 VDD VSS CKBD0
XFE_RC_386_0 FE_RN_52 n1015 n2721 VDD VSS CKND2D8
XFE_RC_382_0 n134 n1315 n13 n1753 VDD VSS IAO21D4
XFE_RC_379_0 n2741 n237 n816 n2745 VDD VSS OAI21D4
XFE_OCPC1135_n2086 n2086 FE_OCPN3441_n2086 VDD VSS CKBD4
XFE_RC_378_0 FE_RN_155 n238 n3620 n342 VDD VSS OAI21D4
XFE_RC_361_0 n206 FE_RN_193_0 VDD VSS CKND1
XFE_RC_360_0 n1498 FE_RN_193_0 FE_RN_194_0 VDD VSS ND2D2
XFE_RC_359_0 n206 FE_RN_195_0 VDD VSS CKND1
XFE_RC_358_0 n1498 FE_RN_195_0 FE_RN_194_0 n1497 VDD VSS OAI21D2
XFE_OCPC1134_n1078 n1078 FE_OCPN3440_n1078 VDD VSS BUFFD8
XFE_RC_342_0 n1347 n3243 FE_RN_181_0 n1408 VDD VSS OAI21D4
XFE_RC_337_0 n3496 FE_OCPN1251_n3494 n2194 n3369 VDD VSS AOI21D4
XFE_RC_336_0 n1652 n874 n857 VDD VSS INR2XD4
XFE_RC_335_0 n70 n273 n1428 n1427 VDD VSS AOI21D4
XFE_RC_332_0 n192 n991 FE_RN_176_0 VDD VSS NR2XD3
XFE_RC_330_0 FE_OFN68_n605 n3657 FE_RN_175_0 VDD VSS ND2D2
XFE_RC_329_0 FE_OCPN1391_FE_OFN68_n605 n3657 FE_RN_175_0 n424 VDD VSS OAI21D4
XFE_RC_328_0 FE_OCPN1233_n1065 n2701 FE_OFN70_n1339 n3408 n2703 VDD VSS AOI31D4
XFE_RC_326_0 n3609 n3225 n3612 n1537 VDD VSS OAI21D4
XFE_RC_323_0 n771 FE_OCPN3476_n80 n606 VDD VSS CKND2D4
XFE_RC_322_0 FE_OCPN3476_n80 n771 FE_RN_174_0 VDD VSS CKND2D4
XFE_RC_320_0 n1754 n3226 n1537 n1536 VDD VSS AOI21D4
XFE_RC_319_0 n199 n2674 FE_RN_173_0 VDD VSS ND2D2
XFE_RC_318_0 FE_RN_173_0 FE_RN_172_0 VDD VSS INVD2
XFE_RC_317_0 FE_RN_172_0 n1014 n836 VDD VSS ND2D3
XFE_RC_316_0 n1073 n1074 n2346 n2470 n2471 VDD VSS OAI22D4
XFE_RC_308_0 n2050 n3163 FE_RN_167_0 VDD VSS NR2D2
XFE_RC_307_0 FE_OFN101_n3160 FE_RN_167_0 FE_RN_168_0 VDD VSS IND2D2
XFE_RC_306_0 n591 FE_RN_168_0 n2293 VDD VSS CKND2D4
XFE_RC_305_0 n615 n543 n2963 n542 VDD VSS OAI21D4
XFE_RC_297_0 FE_RN_16 n202 FE_RN_58_0 n2029 VDD VSS OAI21D4
XFE_RC_296_0 n994 FE_RN_162_0 VDD VSS CKND2
XFE_RC_295_0 n2450 FE_RN_162_0 FE_RN_163_0 VDD VSS CKND2D4
XFE_RC_294_0 n994 FE_RN_164_0 VDD VSS CKND2
XFE_RC_293_0 n2450 FE_RN_164_0 FE_RN_163_0 FE_RN_12 VDD VSS OAI21D4
XU2888_dup FE_RN_1 n2383 FE_RN_67 FE_RN_14 VDD VSS OAI21D4
XFE_RC_286_0 n3637 FE_RN_155_0 VDD VSS CKND2
XFE_RC_285_0 FE_RN_35 FE_RN_155_0 FE_RN_156_0 VDD VSS CKND2D2
XFE_RC_284_0 n3637 FE_RN_157_0 VDD VSS CKND1
XFE_RC_283_0 FE_OCPN1265_n3217 FE_RN_157_0 FE_RN_156_0 n2285 VDD VSS OAI21D4
XFE_RC_268_0 n1508 FE_RN_110 n813 n2473 VDD VSS OAI21D4
XFE_RC_267_0 n3483 n3482 FE_RN_143_0 VDD VSS ND2D4
XFE_RC_266_0 n3483 n3482 FE_RN_143_0 shared_plane[14] VDD VSS OAI21D4
XFE_RC_265_0 FE_OFN70_n1339 n2723 n324 n2732 VDD VSS AOI21D4
XFE_RC_264_0 n1616 FE_RN_140_0 VDD VSS CKND4
XFE_RC_263_0 n3459 FE_RN_140_0 FE_RN_141_0 VDD VSS CKND2D4
XFE_RC_262_0 n1616 FE_RN_142_0 VDD VSS INVD4
XFE_RC_261_0 n3459 FE_RN_142_0 FE_RN_141_0 shared_plane[19] VDD VSS OAI21D4
XU2412_dup FE_RN_139 n191 FE_RN_13 VDD VSS ND2D8
XFE_RC_259_0 n3756 FE_RN_138_0 VDD VSS INVD1
XFE_RC_258_0 FE_RN_138_0 n400 FE_RN_139_0 VDD VSS IND2D4
XFE_RC_257_0 FE_RN_139_0 n1818 base_plane[16] VDD VSS ND2D8
XFE_RC_255_0 n312 FE_RN_136_0 VDD VSS CKND2
XFE_RC_254_0 n622 FE_RN_136_0 FE_RN_137_0 VDD VSS IND2D2
XFE_RC_253_0 n2712 n3065 FE_RN_137_0 n3523 VDD VSS OAI21D4
XFE_RC_251_0 n3035 FE_RN_133_0 VDD VSS CKND1
XFE_RC_250_0 n568 FE_RN_133_0 FE_RN_134_0 VDD VSS CKND2D2
XFE_RC_249_0 n3035 FE_RN_135_0 VDD VSS CKND1
XFE_RC_248_0 n568 FE_RN_135_0 FE_RN_134_0 n567 VDD VSS OAI21D2
XFE_RC_242_0 n1930 FE_RN_128_0 VDD VSS CKND2
XFE_RC_241_0 n1303 FE_RN_128_0 FE_RN_129_0 VDD VSS CKND2D4
XFE_RC_240_0 n1930 FE_RN_130_0 VDD VSS CKND2
XFE_RC_239_0 n1303 FE_RN_130_0 FE_RN_129_0 n1464 VDD VSS OAI21D4
XFE_RC_236_0 n3396 FE_RN_125_0 VDD VSS CKND1
XFE_RC_235_0 n2080 FE_RN_125_0 FE_RN_126_0 VDD VSS ND2D2
XFE_RC_234_0 n3396 FE_RN_127_0 VDD VSS CKND2
XFE_RC_229_0 n3744 n3743 FE_RN_123_0 VDD VSS ND2D4
XFE_RC_228_0 n3744 n3743 FE_RN_123_0 n2112 VDD VSS OAI21D4
XFE_RC_227_0 n960 n106 FE_RN_122_0 VDD VSS ND2D4
XFE_RC_226_0 n960 n106 FE_RN_122_0 n2709 VDD VSS OAI21D4
XFE_RC_225_0 n187 FE_RN_119_0 VDD VSS INVD4
XFE_RC_224_0 n988 FE_RN_120_0 VDD VSS CKND4
XFE_RC_223_0 FE_RN_120_0 FE_RN_119_0 FE_RN_121_0 VDD VSS ND2D3
XFE_RC_221_0 n2143 n2827 n2141 n2140 VDD VSS ND3D8
XFE_RC_219_0 n1829 FE_RN_118_0 VDD VSS INVD2
XFE_RC_217_0 n2846 n1355 n2848 VDD VSS INR2XD4
XFE_RC_216_0 n1141 n1140 FE_RN_117_0 VDD VSS CKND2D2
XFE_RC_215_0 n1141 n1140 FE_RN_117_0 n1139 VDD VSS OAI21D2
XFE_RC_214_0 n117 n2015 FE_RN_116_0 VDD VSS ND2D2
XFE_RC_213_0 n558 FE_RN_116_0 n14 VDD VSS ND2D4
XFE_RC_212_0 n2229 n1971 FE_RN_115_0 VDD VSS NR2D4
XFE_RC_211_0 n877 FE_RN_115_0 n743 VDD VSS INR2XD2
XFE_RC_210_0 n3046 FE_RN_112_0 VDD VSS CKND1
XFE_RC_208_0 n3046 FE_RN_114_0 VDD VSS CKND1
XFE_OCPC1234_n3581 n3581 FE_OCPN1234_n3581 VDD VSS BUFFD2
XFE_RC_206_0 n2739 n2738 n3071 n2740 VDD VSS OAI21D4
XFE_RC_204_0 n3644 n2413 FE_RN_111_0 VDD VSS NR2D3
XFE_RC_203_0 n3647 FE_RN_111_0 n813 VDD VSS INR2D4
XFE_RC_202_0 n1167 n3614 FE_RN_110_0 VDD VSS ND2D2
XFE_RC_200_0 FE_RN_123 n1204 n2125 n1126 VDD VSS OAI21D4
XFE_OCPC1233_n1065 n1065 FE_OCPN1233_n1065 VDD VSS CKBD4
XFE_RC_192_0 n336 n2721 n3071 n335 VDD VSS ND3D8
XFE_OCPC1232_n1746 n1746 FE_OCPN1232_n1746 VDD VSS CKBD1
XFE_RC_191_0 n1581 FE_RN_102_0 VDD VSS CKND4
XFE_RC_190_0 n2662 FE_RN_102_0 FE_RN_103_0 VDD VSS CKND2D4
XFE_RC_189_0 n1581 FE_RN_104_0 VDD VSS INVD3
XFE_RC_188_0 n2662 FE_RN_104_0 FE_RN_103_0 n1315 VDD VSS OAI21D4
XFE_RC_187_0 n3542 FE_RN_99_0 VDD VSS INVD1
XFE_RC_186_0 FE_RN_99_0 FE_RN_103 FE_RN_100_0 VDD VSS ND2D4
XFE_RC_185_0 n3542 FE_RN_101_0 VDD VSS CKND1
XFE_RC_184_0 FE_RN_103 FE_RN_101_0 FE_RN_100_0 n830 VDD VSS OAI21D4
XFE_RC_183_0 n2908 FE_RN_96_0 VDD VSS INVD2
XFE_RC_182_0 FE_OFN1386_n1629 FE_RN_96_0 FE_RN_97_0 VDD VSS ND2D8
XFE_RC_181_0 n2908 FE_RN_98_0 VDD VSS INVD2
XFE_RC_180_0 FE_RN_73 FE_RN_98_0 FE_RN_97_0 n1248 VDD VSS OAI21D4
XFE_OCPC1127_n696 FE_RN_25_0 FE_OFN2792_n546 VDD VSS INVD6
XFE_OCPC1126_n696 n696 FE_RN_25_0 VDD VSS INVD6
XFE_OCPC1231_n3457 n3457 FE_OCPN1231_n3457 VDD VSS BUFFD2
XFE_OCPC1229_n2846 n2846 FE_OCPN1229_n2846 VDD VSS BUFFD2
XFE_RC_174_0 n2767 n3734 n1940 n411 VDD VSS OAI21D4
XFE_RC_173_0 n2671 n2089 n2088 n1460 VDD VSS OAI21D4
XFE_OCPC1226_n1359 n1359 FE_OCPN1226_n1359 VDD VSS BUFFD2
XU3255_dup n1590 n3494 FE_RN_11 VDD VSS CKND2D4
XFE_RC_155_0_dup FE_RN_16 n1860 FE_RN_32 FE_RN_10 VDD VSS AOI21D4
XFE_OCPC1220_n2781 FE_OCPN1529_n2781 FE_OCPN1220_n2781 VDD VSS BUFFD2
XFE_OCPC1219_n2342 n2342 FE_OCPN1219_n2342 VDD VSS BUFFD4
XFE_RC_169_0 n2441 n136 n419 n2283 VDD VSS OAI21D2
XFE_RC_168_0 n1715 FE_RN_90_0 VDD VSS INVD4
XFE_RC_167_0 n959 FE_RN_90_0 FE_RN_91_0 VDD VSS CKND2D3
XFE_RC_166_0 n1715 FE_RN_92_0 VDD VSS INVD2
XFE_RC_165_0 n959 FE_RN_92_0 FE_RN_91_0 n870 VDD VSS OAI21D4
XFE_OCPC1218_n550 n550 FE_OCPN1218_n550 VDD VSS CKBD4
XFE_OCPC1217_n2747 n2747 FE_OCPN1217_n2747 VDD VSS BUFFD4
XFE_RC_161_0 n956 FE_RN_87_0 VDD VSS CKND2
XFE_RC_157_0 n2040 n2554 n2653 VDD VSS ND2D2
XFE_RC_156_0 n2040 n2554 FE_OFN74_n2653 VDD VSS ND2D4
XFE_OCPC1214_n972 n972 FE_OCPN1214_n972 VDD VSS CKBD1
XFE_OCPC1212_n3365 n3365 FE_OCPN1212_n3365 VDD VSS BUFFD2
XFE_RC_155_0 n2039 n1860 n1859 n696 VDD VSS AOI21D4
XFE_RC_154_0 n380 n265 n267 n623 VDD VSS AOI21D4
XFE_RC_153_0 n3648 FE_RN_81_0 VDD VSS CKND1
XFE_RC_151_0 n3648 FE_RN_83_0 VDD VSS CKND1
XFE_OCPC1205_n2117 n2117 FE_OCPN1205_n2117 VDD VSS BUFFD2
XFE_OCPC1204_n3352 n3352 FE_OCPN1204_n3352 VDD VSS BUFFD2
XFE_RC_148_0 n1551 FE_RN_78_0 VDD VSS INVD2
XFE_RC_147_0 n1328 FE_RN_78_0 FE_RN_79_0 VDD VSS CKND2D2
XFE_RC_146_0 n1551 FE_RN_80_0 VDD VSS CKND1
XFE_OCPC1203_n982 n982 FE_OCPN1203_n982 VDD VSS CKBD1
XFE_OCPC1201_n3600 n3600 FE_OCPN1201_n3600 VDD VSS BUFFD2
XFE_OCPC1199_n1138 n1138 FE_OCPN1199_n1138 VDD VSS CKBD0
XFE_OCPC1198_n3690 n3690 FE_OCPN1198_n3690 VDD VSS CKBD1
XFE_OCPC1197_n3489 n3489 FE_OCPN1197_n3489 VDD VSS CKBD1
XFE_OCPC1196_n883 n883 FE_OCPN1196_n883 VDD VSS BUFFD2
XFE_OCPC1195_n2831 FE_OFN1374_n2831 FE_OCPN1195_n2831 VDD VSS BUFFD4
XFE_OCPC1193_n2839 n2839 FE_OCPN1193_n2839 VDD VSS CKBD4
XFE_OCPC1192_n1640 n1640 FE_OCPN1192_n1640 VDD VSS BUFFD4
XFE_OCPC1191_n3534 n3534 FE_OCPN1191_n3534 VDD VSS BUFFD4
XFE_OCPC1190_n1357 n1357 FE_OCPN1190_n1357 VDD VSS BUFFD2
XFE_OCPC1188_n3490 FE_OCPN1286_n3490 FE_OCPN1188_n3490 VDD VSS BUFFD4
XFE_OCPC1187_n1844 n1844 FE_OCPN1187_n1844 VDD VSS BUFFD4
XFE_OCPC1185_n3745 FE_RN_28 FE_OCPN1185_n3745 VDD VSS CKBD4
XFE_OCPC1181_FE_OFN105_n1078 FE_OFN105_n1078 FE_OCPN1181_FE_OFN105_n1078 VDD
+ VSS CKBD1
XFE_OCPC1180_n1776 n1776 FE_OCPN1180_n1776 VDD VSS CKBD1
XU944_dup FE_RN_24 n3497 n1023 FE_RN_9 VDD VSS AOI21D4
XFE_RC_143_0 n701 n702 n2252 n2114 VDD VSS OAI21D4
XFE_OCPC1178_n3485 n3485 FE_OCPN1178_n3485 VDD VSS BUFFD4
XFE_RC_141_0 FE_OCPN1570_n21 FE_RN_75_0 VDD VSS INVD2
XFE_RC_140_0 n2161 FE_RN_75_0 FE_RN_76_0 VDD VSS IND2D2
XFE_RC_138_0 FE_RN_77_0 FE_RN_76_0 n1561 VDD VSS ND2D4
XFE_OCPC1175_n1053 FE_OFN1365_n1053 FE_OCPN1175_n1053 VDD VSS BUFFD4
XFE_OCPC1173_n3357 n3357 FE_OCPN1173_n3357 VDD VSS CKBD1
XFE_OCPC1167_n669 n669 FE_OCPN1167_n669 VDD VSS BUFFD4
XFE_OCPC1165_n178 FE_OCPN3475_n178 FE_OCPN1165_n178 VDD VSS CKBD0
XFE_OCPC1157_n1609 n1609 FE_OCPN1157_n1609 VDD VSS CKBD0
XFE_OCPC1156_n711 n711 FE_OCPN1156_n711 VDD VSS CKBD0
XFE_OCPC1153_n2688 FE_OCPN1540_n2475 FE_OCPN1153_n2688 VDD VSS BUFFD4
XFE_RC_137_0 n1560 FE_OCPN1429_n1148 n869 n868 VDD VSS OAI21D4
XFE_RC_135_0 FE_RN_74_0 n2382 VDD VSS CKND4
XFE_RC_134_0 n2381 n1241 n2206 FE_RN_74_0 VDD VSS OAI21D4
XFE_RC_131_0 n2261 FE_RN_70_0 VDD VSS INVD4
XFE_RC_130_0 n3351 n1137 FE_RN_70_0 FE_RN_71_0 VDD VSS AOI21D4
XFE_RC_129_0 n3352 n1137 FE_RN_72_0 VDD VSS ND2D4
XFE_OCPC1152_n2967 FE_RN_9 FE_OCPN1152_n2967 VDD VSS BUFFD4
XFE_RC_125_0 n2666 n599 FE_RN_67_0 VDD VSS IND2D1
XFE_RC_124_0 n2666 n599 FE_RN_68_0 VDD VSS INR2D2
XFE_RC_123_0 FE_RN_68_0 FE_RN_67_0 n1658 VDD VSS IND2D4
XFE_RC_122_0 n1545 FE_RN_65_0 VDD VSS CKND1
XFE_RC_121_0 n2402 FE_RN_65_0 FE_RN_66_0 VDD VSS IND2D2
XFE_RC_120_0 n2185 FE_OFN3415_n2534 FE_RN_66_0 n2410 VDD VSS OAI21D4
XFE_RC_119_0 n677 FE_RN_62_0 VDD VSS INVD2
XFE_RC_118_0 FE_OFN1374_n2831 FE_RN_62_0 FE_RN_63_0 VDD VSS ND2D4
XFE_RC_117_0 n677 FE_RN_64_0 VDD VSS CKND2
XFE_RC_116_0 FE_OCPN1195_n2831 FE_RN_64_0 FE_RN_63_0 n676 VDD VSS OAI21D4
XFE_RC_114_0 n11 FE_RN_59_0 VDD VSS CKND2
XFE_RC_113_0 n12 FE_RN_59_0 FE_RN_60_0 VDD VSS CKND2D4
XFE_RC_112_0 n11 FE_RN_61_0 VDD VSS CKND2
XFE_RC_111_0 n12 FE_RN_61_0 FE_RN_60_0 shared_plane[28] VDD VSS OAI21D4
XFE_RC_110_0 n202 FE_RN_16 FE_RN_58_0 VDD VSS CKND2D4
XFE_RC_108_0 n469 FE_RN_55_0 VDD VSS CKND1
XFE_RC_107_0 n1487 FE_RN_55_0 FE_RN_56_0 VDD VSS ND2D4
XFE_RC_106_0 n469 FE_RN_57_0 VDD VSS CKND1
XFE_RC_105_0 n1487 FE_RN_57_0 FE_RN_56_0 n401 VDD VSS OAI21D4
XFE_RC_103_0 n2721 n1923 n2716 n1922 n1921 VDD VSS AOI31D4
XFE_RC_100_0 FE_OCPN1543_n701 FE_PSN1635_n702 n2252 n123 VDD VSS OAI21D4
XFE_OCPC1146_FE_OFN2808_shared_plane_22 FE_OCPN1317_FE_OFN2808_shared_plane_22
+ FE_OCPN1146_FE_OFN2808_shared_plane_22 VDD VSS CKBD0
XFE_OCPC1144_n2208 n2208 FE_OCPN1144_n2208 VDD VSS BUFFD4
XFE_RC_89_0 FE_RN_18_0 FE_OCPN1156_n711 n1608 VDD VSS IND2D2
XFE_RC_88_0 FE_RN_18_0 FE_RN_46_0 VDD VSS INVD2
XFE_RC_87_0 FE_RN_46_0 n711 FE_RN_47_0 VDD VSS ND2D3
XFE_RC_86_0 FE_RN_47_0 n1609 shared_plane[17] VDD VSS ND2D8
XFE_RC_79_0 FE_OCPN1250_shared_plane_24 n100 FE_RN_40_0 VDD VSS ND2D1
XFE_RC_78_0 n3398 FE_RN_41_0 VDD VSS CKND2
XFE_RC_76_0 FE_RN_42_0 FE_RN_40_0 mantissa_value[24] VDD VSS ND2D8
XFE_OCPC1143_n3459 n3459 FE_OCPN1143_n3459 VDD VSS CKBD0
XFE_OCPC1137_shared_plane_26 FE_OCPN1301_shared_plane_26
+ FE_OCPN1137_shared_plane_26 VDD VSS CKBD1
XFE_RC_72_0 n3069 FE_RN_38_0 VDD VSS INVD1
XFE_RC_69_0 n3376 n1150 n1815 n2068 VDD VSS OAI21D4
XU195_dup n682 n2982 FE_RN_5 VDD VSS CKND2D3
XFE_RC_67_0 n3664 n3666 n3667 n2174 VDD VSS OAI21D4
XFE_RC_64_0 n3398 FE_RN_36_0 VDD VSS INVD1
XFE_RC_63_0 FE_RN_36_0 divided_plane[25] FE_RN_37_0 VDD VSS IND2D4
XFE_RC_62_0 FE_RN_37_0 n2649 mantissa_value[25] VDD VSS ND2D8
XFE_RC_60_0 n2766 n2208 FE_RN_34_0 VDD VSS IND2D2
XFE_RC_59_0 n2766 FE_RN_35_0 VDD VSS CKND2
XFE_RC_58_0 FE_OCPN1144_n2208 FE_RN_35_0 FE_RN_34_0 shared_plane[20] VDD VSS
+ OAI21D4
XFE_RC_57_0 n3654 FE_RN_31_0 VDD VSS CKND1
XFE_RC_56_0 n32 FE_RN_31_0 FE_RN_32_0 VDD VSS CKND2D2
XFE_RC_55_0 n3654 FE_RN_33_0 VDD VSS CKND1
XU3572_dup FE_RN_15 FE_RN_11 n2367 FE_RN_3 VDD VSS OAI21D4
XU3579_dup n3488 n2370 FE_RN_17 FE_RN_2 VDD VSS AOI21D4
XU3624_dup n3455 n2380 n2379 FE_RN_1 VDD VSS AOI21D4
XFE_RC_50_0 n105 FE_RN_28_0 VDD VSS CKND1
XFE_RC_49_0 n1689 FE_RN_28_0 FE_RN_29_0 VDD VSS IND2D2
XFE_RC_48_0 n948 FE_OFN3483_n59 FE_RN_29_0 n2702 VDD VSS OAI21D4
XFE_RC_44_0 n1363 FE_RN_24_0 VDD VSS INVD4
XFE_RC_42_0 FE_OFN2792_n546 FE_OCPN1601_n1363 FE_RN_25_0 FE_RN_24_0 n1362 VDD
+ VSS OAI22D4
XFE_RC_34_0 FE_RN_13 FE_OFN1334_n2456 n2458 n187 VDD VSS ND3D8
XFE_RC_32_0 FE_OCPN1276_n3351 FE_RN_19_0 VDD VSS INVD2
XFE_RC_31_0 FE_RN_19_0 n3353 FE_RN_18_0 VDD VSS ND2D2
XFE_RC_26_0 n3363 FE_RN_13_0 VDD VSS INVD2
XFE_RC_25_0 n3364 FE_RN_13_0 FE_RN_14_0 VDD VSS CKND2D4
XFE_RC_24_0 n3363 FE_RN_15_0 VDD VSS INVD2
XFE_RC_23_0 n3364 FE_RN_15_0 FE_RN_14_0 shared_plane[21] VDD VSS OAI21D4
XFE_RC_22_0 n1713 n253 FE_RN_12_0 VDD VSS ND2D1
XFE_RC_20_0 n3359 FE_RN_9_0 VDD VSS INVD2
XFE_RC_18_0 n3359 FE_RN_11_0 VDD VSS CKND1
XFE_RC_17_0 FE_RN_77 FE_RN_11_0 FE_RN_10_0 shared_plane[16] VDD VSS OAI21D4
XFE_RC_15_0 FE_RN_84 n2849 n2848 n2176 VDD VSS OAI21D4
XFE_RC_14_0 n3811 FE_RN_7_0 VDD VSS CKND2
XFE_RC_12_0 FE_RN_8_0 n762 base_plane[10] VDD VSS ND2D8
XFE_OFC1120_n256 n256 FE_OFN3431_n256 VDD VSS CKBD1
XFE_OFC1119_n256 n256 n35 VDD VSS CKND1
XFE_OFC1118_n3152 n3152 n291 VDD VSS CKND1
XFE_OFC1117_n2731 n2731 n2238 VDD VSS CKND2
XFE_OFC1116_n3759 n3759 n3434 VDD VSS CKND1
XFE_OFC1115_n2298 n2298 n1645 VDD VSS CKND4
XFE_OFC1114_n2438 FE_OFN3429_n2438 FE_OFN3430_n2438 VDD VSS CKND2
XFE_OFC1113_n2438 n3103 FE_OFN3429_n2438 VDD VSS BUFFD2
XFE_OFC1112_n2438 n3103 FE_OFN3428_n2438 VDD VSS CKND1
XFE_OFC1111_n2438 n2510 FE_OFN3427_n2438 VDD VSS CKND1
XFE_OFC1110_n2438 n2442 FE_OFN3426_n2438 VDD VSS BUFFD2
XFE_OFC1109_n2438 n2442 FE_OFN3425_n2438 VDD VSS CKND2
XFE_OFC1108_n2438 n2432 n2499 VDD VSS BUFFD2
XFE_OFC1107_n2438 n2432 n3103 VDD VSS INVD4
XFE_OFC1106_n2438 n2432 n2183 VDD VSS CKND1
XFE_OFC1105_n2438 n2432 n1545 VDD VSS CKND1
XFE_OFC1104_n2438 n2210 n2520 VDD VSS CKND1
XFE_OFC1103_n2438 n2210 n2510 VDD VSS INVD3
XFE_OFC1102_n2438 n2210 n2442 VDD VSS CKND2
XFE_OFC1101_n2438 n2438 n2432 VDD VSS CKND2
XFE_OFC1100_n2438 n2438 n2210 VDD VSS CKND3
XFE_OFC1099_n2438 n2438 n2515 VDD VSS CKND1
XFE_OFC1098_n2438 n2438 n1271 VDD VSS INVD4
XFE_OFC1097_n3467 n1564 n3285 VDD VSS CKND2
XFE_OFC1096_n3467 n3467 n1564 VDD VSS CKND2
XFE_OFC1095_n3693 n3693 n1599 VDD VSS CKND2
XFE_OFC1092_n1728 n3832 FE_OFN3423_n1728 VDD VSS INVD2
XFE_OFC1091_n1728 n1728 n3832 VDD VSS BUFFD3
XFE_OFC1090_n1728 n1728 n666 VDD VSS BUFFD2
XFE_OFC1089_n3415 n3415 n3182 VDD VSS CKND1
XFE_OFC1085_shared_plane_3 FE_OFN3421_shared_plane_3 FE_OFN3422_shared_plane_3
+ VDD VSS CKND0
XFE_OFC1084_shared_plane_3 shared_plane[3] FE_OFN3421_shared_plane_3 VDD VSS
+ CKND6
XFE_OFC1077_n2829 n2141 FE_OFN3420_n2829 VDD VSS CKND2
XFE_OFC1076_n2829 n2829 n2141 VDD VSS CKND4
XFE_OFC1075_n3824 n3824 n3827 VDD VSS CKND2
XFE_OFC1074_n3224 n310 FE_OFN3419_n3224 VDD VSS BUFFD2
XFE_OFC1073_n3224 n310 FE_OFN3418_n3224 VDD VSS CKND1
XFE_OFC1072_n3224 n3695 FE_OFN3417_n3224 VDD VSS CKND3
XFE_OFC1071_n3224 n306 n310 VDD VSS BUFFD4
XFE_OFC1070_n3224 n306 n3607 VDD VSS CKND1
XFE_OFC1069_n3224 n306 n3695 VDD VSS CKND8
XFE_OFC1068_n3224 n3224 n306 VDD VSS INVD3
XFE_OFC1067_n3562 n3562 n1566 VDD VSS CKND2
XFE_OFC1063_shared_plane_9 shared_plane[9] FE_OFN2764_shared_plane_9 VDD VSS
+ INVD6
XFE_OFC1062_n3049 n3049 n534 VDD VSS INVD2
XFE_OFC1061_n3577 n1289 n1856 VDD VSS CKND1
XFE_OFC1060_n3577 n3577 n1289 VDD VSS CKND2
XFE_OFC1059_n319 n319 FE_OFN2805_y_13 VDD VSS BUFFD3
XFE_OFC1058_n319 n319 FE_OFN2804_y_13 VDD VSS CKND1
XFE_OFC1056_n2644 n2644 n2646 VDD VSS CKND1
XFE_OFC1053_n2306 n2306 n3216 VDD VSS INVD3
XFE_OFC1052_y_20 n2523 n304 VDD VSS INVD6
XFE_OFC1051_y_20 n2523 n2537 VDD VSS CKND2
XFE_OFC1050_y_20 n2595 n1574 VDD VSS CKND2
XFE_OFC1047_y_20 n1983 n2608 VDD VSS CKND1
XFE_OFC1046_y_20 n1732 n2599 VDD VSS CKND1
XFE_OFC1045_y_20 n1732 n2523 VDD VSS INVD3
XFE_OFC1044_y_20 n1732 n2595 VDD VSS CKND2
XFE_OFC1042_y_20 n293 n1983 VDD VSS CKND4
XFE_OFC1041_y_20 n3053 n1732 VDD VSS CKND4
XFE_OFC1040_y_20 n3053 n1731 VDD VSS CKND1
XFE_OFC1039_y_20 n3053 n1730 VDD VSS CKND1
XFE_OFC1038_y_20 n1810 n1729 VDD VSS INVD4
XFE_OFC1037_y_20 n1810 add_x_7_B_19_ VDD VSS CKND1
XFE_OFC1036_y_20 n1810 n293 VDD VSS CKND2
XFE_OFC1035_y_20 y_mantissa[20] n3053 VDD VSS INVD4
XFE_OFC1034_y_20 y_mantissa[20] n1810 VDD VSS CKND1
XFE_OFC1032_n1840 n1840 n1835 VDD VSS CKND2
XFE_OFC1031_n1851 FE_RN_123 n1630 VDD VSS CKND12
XFE_OFC1030_n1851 FE_RN_123 n61 VDD VSS CKND12
XFE_OFC1028_n1760 n1760 n600 VDD VSS INVD2
XFE_OFC1027_n3004 n3004 n311 VDD VSS CKND2
XFE_OFC1023_n2647 n2647 n2648 VDD VSS CKND2
XFE_OFC1022_n2979 n2979 n1669 VDD VSS CKND1
XFE_OFC1021_n2534 n2446 FE_OFN3415_n2534 VDD VSS CKND1
XFE_OFC1020_n2534 n3065 n2446 VDD VSS CKND2
XFE_OFC1019_n2534 n2575 n2150 VDD VSS CKND2
XFE_OFC1018_n2534 n312 n3065 VDD VSS CKND2
XFE_OFC1017_n2534 n2047 n2575 VDD VSS INVD4
XFE_OFC1016_n2534 n2047 n312 VDD VSS CKND2
XFE_OFC1015_n2534 n2534 n2047 VDD VSS CKND4
XFE_OFC1014_n2534 n2534 n298 VDD VSS BUFFD3
XFE_OFC1012_n47 n47 n1635 VDD VSS CKND1
XFE_OFC1011_n47 n47 n3199 VDD VSS CKND2
XFE_OFC1003_n378 n378 FE_OFN65_n378 VDD VSS BUFFD12
XFE_OFC1002_n2973 n2973 n2386 VDD VSS INVD4
XFE_OFC1001_y_17 FE_OFN2759_y_17 n1642 VDD VSS CKND1
XFE_OFC1000_y_17 FE_OFN2759_y_17 n2487 VDD VSS CKND1
XFE_OFC999_y_17 y_mantissa[17] FE_OFN2759_y_17 VDD VSS CKND2
XFE_OFC998_y_17 y_mantissa[17] FE_OFN3409_y_17 VDD VSS CKND2
XFE_OFC996_n2722 n2722 n1444 VDD VSS INVD4
XFE_OFC990_n2917 n2917 n2910 VDD VSS CKND1
XFE_OFC986_n2730 n889 FE_OFN3412_n2730 VDD VSS CKND2
XFE_OFC985_n2730 n2730 n889 VDD VSS INVD4
XFE_OFC984_n3402 n3402 n3176 VDD VSS CKND1
XFE_OFC983_n2245 n2245 n966 VDD VSS CKND4
XFE_OFC982_n3284 n3284 n3091 VDD VSS INVD2
XFE_OFC981_n2670 n2670 FE_OFN3411_n2670 VDD VSS CKND2
XFE_OFC980_n2670 n2670 n316 VDD VSS INVD2
XFE_OFC979_n2609 n2607 FE_OFN3410_n2609 VDD VSS CKND1
XFE_OFC978_n2609 n2609 n2607 VDD VSS CKND2
XFE_OFC977_n3769 n3769 n510 VDD VSS CKND1
XFE_OFC966_n3411 n3411 n3183 VDD VSS CKND1
XFE_OFC965_n1997 n1997 n3701 VDD VSS CKND1
XFE_OFC964_n3033 n3033 n1947 VDD VSS CKND1
XFE_OFC958_n2699 n2656 n2723 VDD VSS CKND1
XFE_OFC957_n2699 n2699 n2656 VDD VSS CKND2
XFE_OFC956_n2664 n2664 n2661 VDD VSS CKND2
XFE_OFC952_n960 n1631 n1685 VDD VSS INVD6
XFE_OFC951_n960 FE_OCPN1227_FE_OFN22_x_5 n941 VDD VSS INVD8
XFE_OFC950_n895 n895 n290 VDD VSS CKND4
XFE_OFC944_n1010 n1010 n1009 VDD VSS CKND1
XFE_OFC941_n2852 n2852 n2015 VDD VSS CKND2
XFE_OFC935_shared_plane_25 FE_OCPN1237_shared_plane_25
+ FE_OFN2728_shared_plane_25 VDD VSS CKND1
XFE_OFC933_n2459 n2459 FE_OFN105_n1078 VDD VSS CKND4
XFE_OFC930_n3639 n3639 n278 VDD VSS CKND6
XFE_OFC929_n3555 n3555 n110 VDD VSS CKND1
XFE_OFC928_n3555 n3555 n112 VDD VSS CKND2
XFE_OFC927_n3555 n3555 n111 VDD VSS CKND2
XFE_OFC926_n3555 n3555 n3741 VDD VSS CKND2
XFE_OFC924_y_7 y_mantissa[7] n2435 VDD VSS INVD2
XFE_OFC923_y_7 y_mantissa[7] n1519 VDD VSS INVD8
XFE_OFC917_y_21 n3429 n318 VDD VSS CKND1
XFE_OFC916_y_21 n987 n2790 VDD VSS INVD4
XFE_OFC914_y_21 n1726 FE_OFN2731_y_21 VDD VSS CKND1
XFE_OFC913_y_21 n2802 n3256 VDD VSS INVD3
XFE_OFC912_y_21 n2802 n3429 VDD VSS CKND1
XFE_OFC911_y_21 n2802 n325 VDD VSS CKND2
XFE_OFC910_y_21 n3050 n987 VDD VSS INVD4
XFE_OFC909_y_21 n3289 DP_OP_49_177_9047_n57 VDD VSS CKND1
XFE_OFC908_y_21 n3289 n326 VDD VSS CKND4
XFE_OFC907_y_21 n2733 n53 VDD VSS INVD4
XFE_OFC906_y_21 n3305 n1725 VDD VSS BUFFD3
XFE_OFC905_y_21 n3305 n1726 VDD VSS CKND1
XFE_OFC904_y_21 n2726 n1577 VDD VSS CKND1
XFE_OFC903_y_21 n2726 n2789 VDD VSS BUFFD3
XFE_OFC902_y_21 n2726 n2802 VDD VSS CKND2
XFE_OFC901_y_21 n1724 n3050 VDD VSS CKND4
XFE_OFC900_y_21 n1724 n3289 VDD VSS CKND2
XFE_OFC899_y_21 n1724 n2733 VDD VSS INVD4
XFE_OFC898_y_21 n1724 n3305 VDD VSS CKND2
XFE_OFC897_y_21 y_mantissa[21] n2726 VDD VSS BUFFD2
XFE_OFC896_y_21 y_mantissa[21] n1724 VDD VSS INVD4
XFE_OFC895_n3410 n3410 n3200 VDD VSS CKND1
XFE_OFC894_n3209 n281 FE_OFN3405_n3209 VDD VSS CKND1
XFE_OFC893_n3209 n281 FE_OFN3404_n3209 VDD VSS CKND1
XFE_OFC892_n3209 n3209 n281 VDD VSS CKND4
XFE_OFC891_n369 n369 n936 VDD VSS CKND2
XFE_OFC887_n2674 n2674 n1647 VDD VSS CKND2
XFE_OFC885_n886 n1570 n823 VDD VSS CKND1
XFE_OFC881_n1269 n1269 n1268 VDD VSS CKND1
XFE_OFC880_n2915 n2915 n2032 VDD VSS CKND1
XFE_OFC878_n270 n270 n513 VDD VSS CKND1
XFE_OFC875_n201 n201 n361 VDD VSS CKND2
XFE_OFC871_x_2 FE_OCPN1192_n1640 n96 VDD VSS CKND2
XFE_OFC870_x_2 n2696 n1640 VDD VSS CKND8
XFE_OFC869_x_2 x_mantissa[2] n2694 VDD VSS INVD4
XFE_OFC868_x_2 x_mantissa[2] n2696 VDD VSS INVD8
XFE_OFC867_x_13 n69 n1476 VDD VSS BUFFD2
XFE_OFC866_x_13 n489 n2841 VDD VSS CKND2
XFE_OFC865_x_13 n489 n68 VDD VSS INVD3
XFE_OFC864_x_13 x_mantissa[13] n69 VDD VSS INVD4
XFE_OFC863_x_13 x_mantissa[13] n489 VDD VSS INVD6
XFE_OFC852_n3096 n3096 n3107 VDD VSS INVD4
XFE_OFC851_n1232 n1232 FE_OFN2745_y_20 VDD VSS CKND2
XFE_OFC848_n766 n766 n622 VDD VSS CKND4
XFE_OFC846_csa_carry_1_11 csa_carry_1[11] n1824 VDD VSS CKND4
XFE_OFC845_x_17 n2871 n3166 VDD VSS CKND1
XFE_OFC844_x_17 n1398 n2871 VDD VSS CKND1
XFE_OFC843_x_17 n1705 n1704 VDD VSS CKND2
XFE_OFC842_x_17 n1705 n1398 VDD VSS CKND1
XFE_OFC841_x_17 x_mantissa[17] n1705 VDD VSS BUFFD4
XFE_OFC840_n3401 FE_OFN104_n3401 n3192 VDD VSS CKND1
XFE_OFC839_n3697 n3697 n3700 VDD VSS CKND2
XFE_OFC833_n3261 n3261 n821 VDD VSS BUFFD4
XFE_OFC832_y_15 y_mantissa[15] n1123 VDD VSS BUFFD4
XFE_OFC831_y_15 y_mantissa[15] n2397 VDD VSS CKND2
XFE_OFC829_n2538 n2538 n2529 VDD VSS CKND1
XFE_OFC828_n165 n2187 n2089 VDD VSS CKND4
XFE_OFC827_n165 n165 n2187 VDD VSS CKND4
XFE_OFC826_n2892 n2779 FE_OFN2810_n2892 VDD VSS CKND2
XFE_OFC825_n2892 n2892 n2779 VDD VSS INVD3
XFE_OFC822_n3090 n3090 n30 VDD VSS CKND2
XFE_OFC820_n1696 FE_OFN107_n1696 n2295 VDD VSS INVD6
XFE_OFC817_n3215 n3215 n21 VDD VSS CKND4
XFE_OFC816_n2883 n2883 n2134 VDD VSS INVD4
XFE_OFC813_shared_plane_22 FE_OCPN1146_FE_OFN2808_shared_plane_22
+ FE_OFN2809_shared_plane_22 VDD VSS CKND1
XFE_OFC812_shared_plane_22 shared_plane[22] FE_OFN2808_shared_plane_22 VDD VSS
+ INVD6
XFE_OFC811_n3655 n3655 n268 VDD VSS CKND2
XFE_OFC808_shared_plane_28 FE_OCPN1285_shared_plane_28
+ FE_OFN2807_shared_plane_28 VDD VSS CKBD1
XFE_OFC807_n2579 n2579 n2580 VDD VSS INVD2
XFE_OFC803_shared_plane_13 shared_plane[13] FE_OFN2770_shared_plane_13 VDD VSS
+ INVD6
XFE_OFC801_n251 n48 n1279 VDD VSS BUFFD2
XFE_OFC800_n251 n251 n48 VDD VSS BUFFD2
XFE_OFC799_n251 n251 FE_OFN109_n251 VDD VSS CKND2
XFE_OFC797_x_7 n97 n2220 VDD VSS CKND1
XFE_OFC796_x_7 n472 n99 VDD VSS INVD6
XFE_OFC795_x_7 n472 n97 VDD VSS INVD2
XFE_OFC794_x_7 x_mantissa[7] n1633 VDD VSS INVD2
XFE_OFC793_x_7 x_mantissa[7] n472 VDD VSS INVD6
XFE_OFC792_x_7 x_mantissa[7] n98 VDD VSS INVD4
XFE_OFC788_n1673 n1673 FE_OFN106_n1673 VDD VSS BUFFD16
XFE_OFC782_shared_plane_25 FE_OFN2728_shared_plane_25
+ FE_OFN2727_shared_plane_25 VDD VSS CKND1
XFE_OFC779_n3353 n3353 n1607 VDD VSS CKND1
XFE_OFC778_n2991 n2816 n2931 VDD VSS CKND2
XFE_OFC777_n2991 n2991 n2816 VDD VSS CKND1
XFE_OFC776_n2991 n2991 n2806 VDD VSS CKND1
XFE_OFC773_y_13 y_mantissa[13] n319 VDD VSS CKND2
XFE_OFC772_y_13 y_mantissa[13] n2782 VDD VSS INVD2
XFE_OFC771_y_13 y_mantissa[13] n1578 VDD VSS CKND1
XFE_OFC768_n3067 n3067 n2890 VDD VSS CKND1
XFE_OFC767_n3067 n3067 n3069 VDD VSS CKND4
XFE_OFC766_x_10 n1100 FE_OFN2739_x_10 VDD VSS CKND1
XFE_OFC765_x_10 n1100 FE_OFN2738_x_10 VDD VSS CKND1
XFE_OFC764_x_10 n55 n1100 VDD VSS CKND2
XFE_OFC763_x_10 n1707 n55 VDD VSS BUFFD2
XFE_OFC762_x_10 x_mantissa[10] n1707 VDD VSS INVD6
XFE_OFC761_x_10 x_mantissa[10] n2419 VDD VSS CKND0
XFE_OFC759_n2600 n3747 FE_OFN2803_n2600 VDD VSS CKND2
XFE_OFC758_n2600 n3747 n3811 VDD VSS INVD2
XFE_OFC757_n2600 n3757 n294 VDD VSS CKND1
XFE_OFC756_n2600 n3757 n3747 VDD VSS CKND1
XFE_OFC755_n2600 n3757 n302 VDD VSS CKND2
XFE_OFC754_n2600 n2600 n2111 VDD VSS CKND1
XFE_OFC753_n2600 n2600 n3757 VDD VSS CKND2
XFE_OFC752_n1544 n1544 n869 VDD VSS CKND2
XFE_OFC751_n3151 n327 n1701 VDD VSS CKND1
XFE_OFC750_n3151 n3151 n327 VDD VSS CKND2
XFE_OFC749_n1847 n3092 n1094 VDD VSS CKND2
XFE_OFC748_n1847 n1847 n502 VDD VSS CKND1
XFE_OFC747_n1847 n1847 n3092 VDD VSS CKND2
XFE_OFC746_n3026 n3026 n483 VDD VSS CKND1
XFE_OFC745_csa_carry_1_17 csa_carry_1[17] n2375 VDD VSS CKND4
XFE_OFC744_n1904 n1904 n1050 VDD VSS INVD6
XFE_OFC742_n1890 n1890 n1889 VDD VSS CKND2
XFE_OFC741_x_22 n3785 FE_OFN2802_x_22 VDD VSS CKND1
XFE_OFC740_x_22 n176 n322 VDD VSS CKND1
XFE_OFC739_x_22 n1576 n3106 VDD VSS INVD6
XFE_OFC738_x_22 n1576 n3071 VDD VSS BUFFD3
XFE_OFC737_x_22 n1576 n2685 VDD VSS CKND6
XFE_OFC736_x_22 n3129 n2149 VDD VSS CKND2
XFE_OFC735_x_22 n1236 n3785 VDD VSS CKND2
XFE_OFC734_x_22 n1236 n1637 VDD VSS BUFFD2
XFE_OFC733_x_22 n1236 n3437 VDD VSS CKBD1
XFE_OFC732_x_22 n3070 n176 VDD VSS CKND1
XFE_OFC731_x_22 n3070 n1576 VDD VSS CKND8
XFE_OFC730_x_22 n3070 n3129 VDD VSS CKND1
XFE_OFC729_x_22 n3070 n1236 VDD VSS CKND2
XFE_OFC728_x_22 x_mantissa[22] n3070 VDD VSS INVD8
XFE_OFC723_x_18 n2824 FE_OFN2754_x_18 VDD VSS CKND1
XFE_OFC722_x_18 n1579 FE_OFN2753_x_18 VDD VSS CKND1
XFE_OFC721_x_18 n1739 n63 VDD VSS CKND1
XFE_OFC720_x_18 n1739 n2824 VDD VSS CKND1
XFE_OFC719_x_18 x_mantissa[18] n3110 VDD VSS CKND1
XFE_OFC718_x_18 x_mantissa[18] n1579 VDD VSS CKND1
XFE_OFC717_x_18 x_mantissa[18] n1739 VDD VSS CKND2
XFE_OFC715_n3172 n3172 FE_OFN102_n3172 VDD VSS BUFFD2
XFE_OFC713_n3203 n3203 n3338 VDD VSS CKND2
XFE_OFC712_n2970 n2970 n2971 VDD VSS CKND1
XFE_OFC711_n3084 n3086 FE_OFN2800_n3084 VDD VSS CKND2
XFE_OFC710_n3084 n3084 n3086 VDD VSS BUFFD3
XFE_OFC708_n3615 n3251 n307 VDD VSS BUFFD3
XFE_OFC707_n3615 n1842 n3628 VDD VSS BUFFD3
XFE_OFC706_n3615 n3625 n3251 VDD VSS CKND2
XFE_OFC705_n3615 n3625 n3638 VDD VSS CKND1
XFE_OFC704_n3615 n299 n3641 VDD VSS BUFFD3
XFE_OFC703_n3615 n299 n1842 VDD VSS CKND2
XFE_OFC702_n3615 n3615 n3658 VDD VSS CKND1
XFE_OFC701_n3615 n3615 n3321 VDD VSS CKND0
XFE_OFC700_n3615 n3615 n3625 VDD VSS CKND1
XFE_OFC699_n3615 n3615 n299 VDD VSS BUFFD4
XFE_OFC693_n3030 n2232 FE_OFN2799_n3030 VDD VSS INVD3
XFE_OFC692_n3030 n2232 FE_OFN2798_n3030 VDD VSS INVD4
XFE_OFC691_n3030 n2232 FE_OFN78_n3030 VDD VSS INVD2
XFE_OFC690_n3030 n3030 n2232 VDD VSS CKND6
XFE_OFC680_n2067 n2067 n1750 VDD VSS CKND2
XFE_OFC678_n1743 FE_OFN2794_n1743 FE_OFN2795_n1743 VDD VSS CKND2
XFE_OFC677_n1743 n1742 FE_OFN2794_n1743 VDD VSS INVD1
XFE_OFC676_n1743 n1742 n700 VDD VSS CKND1
XFE_OFC675_n1743 n1743 n1742 VDD VSS INVD6
XFE_OFC674_n1658 n1658 n1790 VDD VSS INVD6
XFE_OFC673_y_16 FE_OFN3486_n3239 n1688 VDD VSS CKBD1
XFE_OFC672_y_16 n2202 n2485 VDD VSS BUFFD3
XFE_OFC671_y_16 y_mantissa[16] n3239 VDD VSS BUFFD2
XFE_OFC670_y_16 y_mantissa[16] n2202 VDD VSS INVD4
XFE_OFC667_n1378 n1378 n2842 VDD VSS CKND1
XFE_OFC666_n2072 n1339 n1113 VDD VSS CKND1
XFE_OFC665_n2072 n1339 FE_OFN70_n1339 VDD VSS CKND12
XFE_OFC664_n2072 n2072 n1339 VDD VSS INVD4
XFE_OFC663_n1461 n1461 n3044 VDD VSS INVD2
XFE_OFC660_y_19 y_mantissa[19] n2101 VDD VSS CKND4
XFE_OFC659_y_19 y_mantissa[19] n47 VDD VSS INVD2
XFE_OFC642_n1823 FE_OCPN3463_n87 n2805 VDD VSS CKND1
XFE_OFC641_n1823 n87 n3240 VDD VSS INVD8
XFE_OFC640_n1823 n1823 n87 VDD VSS CKND8
XFE_OFC638_n2596 n2596 n254 VDD VSS CKND4
XFE_OFC637_n3795 n3773 FE_OFN2790_n3795 VDD VSS CKND1
XFE_OFC636_n3795 n3795 n3773 VDD VSS CKND2
XFE_OFC635_x_4 n106 FE_OFN2789_x_4 VDD VSS CKND1
XFE_OFC634_x_4 FE_OFN1366_n1641 n818 VDD VSS INVD6
XFE_OFC632_x_4 FE_RN_82 n2713 VDD VSS CKND2
XFE_OFC627_n3022 FE_OFN2786_n3022 FE_OFN2787_n3022 VDD VSS CKND2
XFE_OFC626_n3022 n627 FE_OFN2786_n3022 VDD VSS CKND6
XFE_OFC625_n3022 n627 FE_OFN2785_n3022 VDD VSS INVD2
XFE_OFC624_n3022 n627 FE_OFN77_n3022 VDD VSS CKND1
XFE_OFC623_n3022 n627 n359 VDD VSS INVD2
XFE_OFC622_n3022 n3022 n627 VDD VSS INVD6
XFE_OFC620_n3484 n3484 n3386 VDD VSS INVD2
XFE_OFC618_n2812 n2812 n248 VDD VSS INVD4
XFE_OFC617_n2941 n2941 n2939 VDD VSS CKND6
XFE_OFC609_n2473 n2473 n1200 VDD VSS CKND8
XFE_OFC608_n84 n468 n356 VDD VSS CKND4
XFE_OFC607_n84 n84 n468 VDD VSS CKND6
XFE_OFC605_y_8 n2787 n994 VDD VSS CKND4
XFE_OFC604_y_8 n2901 n2787 VDD VSS INVD6
XFE_OFC603_y_8 y_mantissa[8] n109 VDD VSS INVD4
XFE_OFC602_y_8 y_mantissa[8] n2901 VDD VSS CKND4
XFE_OFC599_y_12 n2776 n465 VDD VSS CKND2
XFE_OFC598_y_12 y_mantissa[12] n1711 VDD VSS BUFFD4
XFE_OFC597_y_12 y_mantissa[12] n2776 VDD VSS INVD4
XFE_OFC593_n3160 n3160 FE_OFN101_n3160 VDD VSS BUFFD8
XFE_OFC592_n2388 n2388 n995 VDD VSS CKND1
XFE_OFC591_n812 n812 n811 VDD VSS CKND4
XFE_OFC590_n1248 n1248 n2234 VDD VSS INVD4
XFE_OFC587_n3052 n3052 n59 VDD VSS BUFFD8
XFE_OFC582_n3371 n3371 n1377 VDD VSS CKND1
XFE_OFC579_n2590 n2590 n168 VDD VSS BUFFD4
XFE_OFC578_y_5 n2655 n1338 VDD VSS CKBD4
XFE_OFC577_y_5 n2655 n1698 VDD VSS INVD4
XFE_OFC576_y_5 n2655 n1699 VDD VSS INVD6
XFE_OFC575_y_5 n807 n2655 VDD VSS CKND8
XFE_OFC574_y_5 n2708 n807 VDD VSS INVD6
XFE_OFC572_n3327 n3327 n778 VDD VSS CKND4
XFE_OFC543_n2450 FE_RN_57 FE_OFN108_n2450 VDD VSS BUFFD16
XFE_OFC542_y_10 n255 FE_OFN98_n300 VDD VSS BUFFD2
XFE_OFC541_y_10 y_mantissa[10] n255 VDD VSS INVD6
XFE_OFC540_y_10 y_mantissa[10] FE_OFN2732_y_10 VDD VSS BUFFD3
XFE_OFC538_n3351 FE_OCPN1276_n3351 n710 VDD VSS INVD2
XFE_OFC535_y_9 n92 n101 VDD VSS INVD8
XFE_OFC534_y_9 y_mantissa[9] n92 VDD VSS INVD8
XFE_OFC526_y_22 n1573 FE_OFN2780_y_22 VDD VSS CKND4
XFE_OFC525_y_22 n1573 n2581 VDD VSS CKND1
XFE_OFC524_y_22 n1573 n3066 VDD VSS CKND1
XFE_OFC523_y_22 n2761 n3073 VDD VSS INVD2
XFE_OFC522_y_22 n3113 n1573 VDD VSS INVD4
XFE_OFC521_y_22 n3113 n3870 VDD VSS CKND1
XFE_OFC520_y_22 n3791 n2761 VDD VSS CKND2
XFE_OFC519_y_22 n3791 n3428 VDD VSS CKND2
XFE_OFC518_y_22 y_mantissa[22] n3113 VDD VSS CKND2
XFE_OFC517_y_22 y_mantissa[22] n3791 VDD VSS CKND2
XFE_OFC500_n2326 n2326 n1465 VDD VSS CKND1
XFE_OFC492_n2457 FE_OFN112_n2457 FE_OFN2777_n2457 VDD VSS INVD8
XFE_OFC491_n2457 FE_OCPN1571_FE_OFN112_n2457 n2458 VDD VSS CKND4
XFE_OFC490_n2457 n2457 FE_OFN112_n2457 VDD VSS INVD6
XFE_OFC471_n2657 n2657 n2056 VDD VSS CKND2
XFE_OFC468_n2601 n2879 FE_OFN2773_n2601 VDD VSS CKND1
XFE_OFC467_n2601 n2879 n1993 VDD VSS CKND2
XFE_OFC466_n2601 n2601 n2879 VDD VSS CKND2
XFE_OFC457_shared_plane_13 FE_OCPN1609_FE_OFN2770_shared_plane_13
+ FE_OFN2771_shared_plane_13 VDD VSS CKND1
XFE_OFC445_n2447 n2164 FE_OFN2768_n2447 VDD VSS CKND1
XFE_OFC444_n2447 n2447 n2164 VDD VSS INVD2
XFE_OFC432_shared_plane_9 FE_OFN2764_shared_plane_9 FE_OFN2765_shared_plane_9
+ VDD VSS CKND1
XFE_OFC388_x_21 n1003 FE_OFN2752_x_21 VDD VSS CKND1
XFE_OFC387_x_21 FE_OFN1359_n323 n261 VDD VSS INVD3
XFE_OFC386_x_21 n324 n3258 VDD VSS CKND1
XFE_OFC385_x_21 n3234 n258 VDD VSS CKND4
XFE_OFC384_x_21 n3234 n2825 VDD VSS INVD2
XFE_OFC383_x_21 n3408 n1971 VDD VSS CKND2
XFE_OFC382_x_21 n3282 n1003 VDD VSS INVD2
XFE_OFC381_x_21 n3438 n262 VDD VSS CKND2
XFE_OFC380_x_21 n2775 n323 VDD VSS INVD2
XFE_OFC379_x_21 FE_OFN1375_n3252 n241 VDD VSS CKND4
XFE_OFC378_x_21 n3252 n324 VDD VSS CKND2
XFE_OFC377_x_21 n2784 n3234 VDD VSS INVD2
XFE_OFC376_x_21 n2784 n3408 VDD VSS CKND2
XFE_OFC375_x_21 n2711 n3282 VDD VSS CKND4
XFE_OFC374_x_21 n259 n3083 VDD VSS BUFFD4
XFE_OFC373_x_21 n259 n3438 VDD VSS CKND1
XFE_OFC372_x_21 n259 n2775 VDD VSS CKND4
XFE_OFC371_x_21 n2725 n3252 VDD VSS CKND2
XFE_OFC370_x_21 n2725 n2784 VDD VSS INVD2
XFE_OFC369_x_21 n2725 n2711 VDD VSS CKND4
XFE_OFC368_x_21 x_mantissa[21] n259 VDD VSS INVD4
XFE_OFC367_x_21 x_mantissa[21] n2725 VDD VSS INVD4
XFE_OFC360_shared_plane_6 FE_PSN1649_FE_OFN2749_shared_plane_6
+ FE_OFN2750_shared_plane_6 VDD VSS CKND1
XFE_OFC359_shared_plane_6 shared_plane[6] FE_OFN2749_shared_plane_6 VDD VSS
+ INVD12
XFE_OFC343_y_20 n2501 FE_OFN2744_y_20 VDD VSS INVD2
XFE_OFC342_y_20 n304 FE_OFN2743_y_20 VDD VSS CKND2
XFE_OFC341_y_20 n2537 n1232 VDD VSS INVD1
XFE_OFC340_y_20 n2537 n296 VDD VSS CKND1
XFE_OFC339_y_20 n2537 n2501 VDD VSS CKND2
XFE_OFC314_x_11 FE_OFN73_n2417 FE_OFN2741_x_11 VDD VSS INVD2
XFE_OFC313_x_11 n629 FE_OFN73_n2417 VDD VSS CKND4
XFE_OFC312_x_11 x_mantissa[11] n629 VDD VSS INVD6
XFE_OFC311_x_11 x_mantissa[11] n2417 VDD VSS CKND0
XFE_OFC310_x_11 x_mantissa[11] n2418 VDD VSS CKND1
XFE_OFC308_n418 n418 n417 VDD VSS CKND2
XFE_OFC307_x_19 n3191 n2504 VDD VSS CKND1
XFE_OFC306_x_19 n3191 n3114 VDD VSS CKND1
XFE_OFC305_x_19 x_mantissa[19] n1636 VDD VSS INVD4
XFE_OFC304_x_19 x_mantissa[19] n3191 VDD VSS CKND1
XFE_OFC301_x_16 n2498 n2803 VDD VSS INVD2
XFE_OFC300_x_16 n2395 n2498 VDD VSS BUFFD2
XFE_OFC299_x_16 n3165 n2395 VDD VSS BUFFD2
XFE_OFC298_x_16 x_mantissa[16] n3165 VDD VSS BUFFD2
XFE_OFC296_n968 n1375 n1376 VDD VSS CKND2
XFE_OFC295_n968 n968 n1375 VDD VSS BUFFD4
XFE_OFC276_n1078 n1078 n2459 VDD VSS CKND4
XFE_OFC275_n1078 FE_OCPN3440_n1078 n703 VDD VSS INVD2
XFE_OFC274_x_14 n1632 n301 VDD VSS CKND1
XFE_OFC273_x_14 n3008 n2833 VDD VSS CKND1
XFE_OFC272_x_14 n161 n1632 VDD VSS CKND4
XFE_OFC271_x_14 x_mantissa[14] n3008 VDD VSS CKND2
XFE_OFC270_x_14 x_mantissa[14] n161 VDD VSS INVD2
XFE_OFC267_level_1 n320 n314 VDD VSS CKND1
XFE_OFC266_level_1 n3678 n2103 VDD VSS CKND1
XFE_OFC265_level_1 n3678 n260 VDD VSS CKND1
XFE_OFC264_level_1 n2737 n313 VDD VSS CKND1
XFE_OFC263_level_1 n3680 n2984 VDD VSS CKND1
XFE_OFC262_level_1 n3680 n320 VDD VSS CKND1
XFE_OFC261_level_1 n3683 n3678 VDD VSS INVD2
XFE_OFC260_level_1 n3397 n3619 VDD VSS CKND1
XFE_OFC259_level_1 n3397 n2737 VDD VSS BUFFD3
XFE_OFC258_level_1 n3397 n3680 VDD VSS CKND1
XFE_OFC257_level_1 n2736 n3528 VDD VSS CKND1
XFE_OFC254_level_1 n2028 n3683 VDD VSS CKND2
XFE_OFC253_level_1 n2028 n3397 VDD VSS CKND1
XFE_OFC252_level_1 n2028 n2736 VDD VSS CKND1
XFE_OFC249_level_1 FE_OFN54_level_1 n2028 VDD VSS CKND4
XFE_OFC248_level_1 level[1] FE_OFN54_level_1 VDD VSS BUFFD3
XFE_OFC233_x_15 n1634 FE_OFN59_n180 VDD VSS BUFFD2
XFE_OFC231_x_15 x_mantissa[15] n2838 VDD VSS BUFFD3
XFE_OFC230_x_15 x_mantissa[15] n1634 VDD VSS INVD4
XFE_OFC228_x_9 n1639 FE_OFN2735_x_9 VDD VSS CKND1
XFE_OFC227_x_9 n2763 n2734 VDD VSS CKND1
XFE_OFC226_x_9 n2763 n1639 VDD VSS CKND6
XFE_OFC225_x_9 FE_OCPN1477_n308 n1638 VDD VSS INVD4
XFE_OFC224_x_9 x_mantissa[9] n2763 VDD VSS INVD4
XFE_OFC220_x_12 n1695 n389 VDD VSS CKND1
XFE_OFC219_x_12 n328 n1695 VDD VSS CKND1
XFE_OFC218_x_12 FE_OFN17_x_12 n328 VDD VSS INVD2
XFE_OFC217_x_12 FE_OFN17_x_12 n2780 VDD VSS CKND1
XFE_OFC216_x_12 x_mantissa[12] FE_OFN17_x_12 VDD VSS INVD4
XFE_OFC211_shared_plane_10 shared_plane[10] n1682 VDD VSS CKND8
XFE_OFC169_x_8 FE_OCPN1256_n2907 n1709 VDD VSS CKND1
XFE_OFC168_x_8 n1708 n65 VDD VSS BUFFD8
XFE_OFC167_x_8 x_mantissa[8] n2907 VDD VSS INVD8
XFE_OFC166_x_8 x_mantissa[8] n1708 VDD VSS INVD4
XFE_OFC162_y_6 n166 n2186 VDD VSS INVD4
XFE_OFC161_y_6 n402 n1411 VDD VSS INVD6
XFE_OFC160_y_6 n402 n166 VDD VSS CKND6
XFE_OFC159_y_6 y_mantissa[6] n402 VDD VSS INVD12
XFE_OFC134_n107 FE_OFN1351_n107 FE_OFN2726_n107 VDD VSS CKND8
XFE_OFC133_n107 FE_OFN1351_n107 FE_OFN2725_n107 VDD VSS CKND8
XFE_OFC132_n107 FE_OFN64_n107 FE_OFN2724_n107 VDD VSS INVD8
XFE_OFC131_n107 FE_OFN64_n107 n108 VDD VSS INVD6
XFE_OFC130_n107 FE_OFN64_n107 n1703 VDD VSS INVD2
XFE_OFC129_n107 n107 FE_OFN64_n107 VDD VSS INVD8
XFE_OFC107_n1696 n1696 FE_OFN107_n1696 VDD VSS BUFFD8
XFE_OFC104_n3401 n3401 FE_OFN104_n3401 VDD VSS CKBD1
XFE_OFC103_n3196 n3196 FE_OFN103_n3196 VDD VSS CKBD1
XFE_OFC72_n1925 n1925 FE_OFN72_n1925 VDD VSS BUFFD4
XFE_OFC55_level_0 level[0] FE_OFN55_level_0 VDD VSS BUFFD4
Xcsa_level_0 VSS VSS VSS VSS base_plane[24] base_plane[23] base_plane[22]
+ base_plane[21] base_plane[20] base_plane[19] base_plane[18] base_plane[17]
+ base_plane[16] base_plane[15] base_plane[14] base_plane[13] base_plane[12]
+ base_plane[11] base_plane[10] base_plane[9] base_plane[8] base_plane[7]
+ base_plane[6] base_plane[5] base_plane[4] base_plane[3] base_plane[2]
+ base_plane[1] n3839 n2311 n3841 n2310 n3861 n2315 n2334 n2301 n2362 n3845
+ n3852 n3860 selected_delta_1[17] n3865 n3858 n3842 n2020 n3856
+ selected_delta_1[11] n3855 n3843 n2347 n3840 n3857 selected_delta_1[5] n3846
+ n3850 n2340 n2305 n3851 n1693 VSS selected_delta_2[26] n1692
+ selected_delta_2[24] selected_delta_2[23] n2361 n2360 n3853 n2343 n2345 n3854
+ n2331 n2344 n3863 n2318 n2319 selected_delta_2[11] selected_delta_2[10] n3864
+ n1655 n3859 n3869 n2321 n3866 selected_delta_2[3] n2322 n2317 n3529
+ csa_sum_0[28] csa_sum_0[27] csa_sum_0[26] csa_sum_0[25] csa_sum_0[24]
+ csa_sum_0[23] csa_sum_0[22] csa_sum_0[21] csa_sum_0[20] csa_sum_0[19]
+ csa_sum_0[18] csa_sum_0[17] csa_sum_0[16] csa_sum_0[15] csa_sum_0[14]
+ csa_sum_0[13] csa_sum_0[12] csa_sum_0[11] csa_sum_0[10] csa_sum_0[9]
+ csa_sum_0[8] csa_sum_0[7] csa_sum_0[6] csa_sum_0[5] csa_sum_0[4] csa_sum_0[3]
+ csa_sum_0[2] csa_sum_0[1] csa_sum_0[0] csa_carry_0[28] csa_carry_0[27]
+ csa_carry_0[26] csa_carry_0[25] csa_carry_0[24] csa_carry_0[23]
+ csa_carry_0[22] csa_carry_0[21] csa_carry_0[20] csa_carry_0[19]
+ csa_carry_0[18] csa_carry_0[17] csa_carry_0[16] csa_carry_0[15]
+ csa_carry_0[14] csa_carry_0[13] csa_carry_0[12] csa_carry_0[11]
+ csa_carry_0[10] csa_carry_0[9] csa_carry_0[8] csa_carry_0[7] csa_carry_0[6]
+ csa_carry_0[5] csa_carry_0[4] csa_carry_0[3] csa_carry_0[2] csa_carry_0[1]
+ SYNOPSYS_UNCONNECTED__0 VDD VSS csa3_WIDTH29_1
Xcsa_level_1 csa_sum_0[28] csa_sum_0[27] csa_sum_0[26] csa_sum_0[25]
+ csa_sum_0[24] csa_sum_0[23] csa_sum_0[22] csa_sum_0[21] csa_sum_0[20]
+ csa_sum_0[19] csa_sum_0[18] csa_sum_0[17] csa_sum_0[16] csa_sum_0[15]
+ csa_sum_0[14] csa_sum_0[13] csa_sum_0[12] csa_sum_0[11] csa_sum_0[10]
+ csa_sum_0[9] csa_sum_0[8] csa_sum_0[7] csa_sum_0[6] csa_sum_0[5] csa_sum_0[4]
+ csa_sum_0[3] csa_sum_0[2] csa_sum_0[1] csa_sum_0[0] csa_carry_0[28]
+ csa_carry_0[27] csa_carry_0[26] csa_carry_0[25] csa_carry_0[24]
+ csa_carry_0[23] csa_carry_0[22] csa_carry_0[21] csa_carry_0[20]
+ csa_carry_0[19] csa_carry_0[18] csa_carry_0[17] csa_carry_0[16]
+ csa_carry_0[15] csa_carry_0[14] csa_carry_0[13] csa_carry_0[12]
+ csa_carry_0[11] csa_carry_0[10] csa_carry_0[9] csa_carry_0[8] csa_carry_0[7]
+ csa_carry_0[6] csa_carry_0[5] csa_carry_0[4] csa_carry_0[3] csa_carry_0[2]
+ csa_carry_0[1] VSS selected_delta_3[24] VSS VSS selected_delta_3[25]
+ selected_delta_3[28] n3849 n3848 n3847 n190 n2359 n2324 selected_delta_3[17]
+ selected_delta_3[16] n3862 selected_delta_3[14] n204 n2355 n220 n1580
+ selected_delta_3[9] selected_delta_3[8] n3867 selected_delta_3[6] n2356 n2299
+ n3868 selected_delta_3[2] n2308 n3525 csa_sum_1[28] csa_sum_1[27]
+ csa_sum_1[26] csa_sum_1[25] csa_sum_1[24] csa_sum_1[23] csa_sum_1[22]
+ csa_sum_1[21] csa_sum_1[20] csa_sum_1[19] csa_sum_1[18] csa_sum_1[17]
+ csa_sum_1[16] csa_sum_1[15] csa_sum_1[14] csa_sum_1[13] csa_sum_1[12]
+ csa_sum_1[11] csa_sum_1[10] csa_sum_1[9] csa_sum_1[8] csa_sum_1[7]
+ csa_sum_1[6] csa_sum_1[5] csa_sum_1[4] csa_sum_1[3] csa_sum_1[2] csa_sum_1[1]
+ shared_plane[0] csa_carry_1[28] csa_carry_1[27] csa_carry_1[26]
+ csa_carry_1[25] csa_carry_1[24] csa_carry_1[23] csa_carry_1[22]
+ csa_carry_1[21] csa_carry_1[20] csa_carry_1[19] csa_carry_1[18]
+ csa_carry_1[17] csa_carry_1[16] csa_carry_1[15] csa_carry_1[14]
+ csa_carry_1[13] csa_carry_1[12] csa_carry_1[11] csa_carry_1[10]
+ csa_carry_1[9] csa_carry_1[8] csa_carry_1[7] csa_carry_1[6] csa_carry_1[5]
+ csa_carry_1[4] csa_carry_1[3] csa_carry_1[2] csa_carry_1[1]
+ SYNOPSYS_UNCONNECTED__1 VDD VSS csa3_WIDTH29_0
Xreciprocal_lut FE_OFN54_level_1 FE_OFN55_level_0 FE_OFN2780_y_22 n987
+ add_x_7_B_19_ reciprocal_square[7] reciprocal_square[6] reciprocal_square[5]
+ reciprocal_square[4] reciprocal_square[3] reciprocal_square[2]
+ reciprocal_square[1] reciprocal_square[0] VDD VSS recip_lut
Xdivision_scale shared_plane[28] shared_plane[27] shared_plane[26]
+ shared_plane[25] shared_plane[24] FE_PSN1632_n178 FE_OFN2808_shared_plane_22
+ shared_plane[21] shared_plane[20] shared_plane[19] shared_plane[18]
+ shared_plane[17] shared_plane[16] n162 shared_plane[14]
+ FE_OFN2770_shared_plane_13 FE_OCPN3454_shared_plane_12 shared_plane[11] n1682
+ FE_OFN2764_shared_plane_9 shared_plane[8] shared_plane[7]
+ FE_OFN2749_shared_plane_6 shared_plane[5] shared_plane[4]
+ FE_OFN3421_shared_plane_3 shared_plane[2] shared_plane[1] shared_plane[0]
+ reciprocal_square[7] reciprocal_square[6] reciprocal_square[5]
+ reciprocal_square[4] reciprocal_square[3] reciprocal_square[2]
+ reciprocal_square[1] reciprocal_square[0] divided_plane[28] divided_plane[27]
+ divided_plane[26] divided_plane[25] divided_plane[24] divided_plane[23]
+ divided_plane[22] divided_plane[21] divided_plane[20] divided_plane[19]
+ divided_plane[18] divided_plane[17] divided_plane[16] divided_plane[15]
+ divided_plane[14] divided_plane[13] divided_plane[12] divided_plane[11]
+ divided_plane[10] divided_plane[9] divided_plane[8] divided_plane[7]
+ divided_plane[6] divided_plane[5] divided_plane[4] divided_plane[3]
+ divided_plane[2] divided_plane[1] divided_plane[0] VDD VSS
+ FE_OCPN3455_shared_plane_12 FE_OCPN3470_shared_plane_25
+ FE_OCPN3472_shared_plane_24 FE_OCPN3475_n178 FE_OCPN3474_n178
+ sa_scale_VALUE_WIDTH29_COEFF_WIDTH8
XU4 shared_plane[11] divided_plane[11] n3835 mantissa_value[11] VDD VSS MUX2D2
XU5 n1682 divided_plane[10] n50 mantissa_value[10] VDD VSS MUX2D4
XU6 shared_plane[7] divided_plane[7] n91 mantissa_value[7] VDD VSS MUX2D2
XU7 shared_plane[4] divided_plane[4] n3836 mantissa_value[4] VDD VSS MUX2D2
XU10 shared_plane[0] divided_plane[0] n91 mantissa_value[0] VDD VSS MUX2D2
XU11 n3067 n3398 VDD VSS INVD2
XU12 n2956 n11 VDD VSS CKND2
XU13 n2951 FE_RN_95 n2950 n2952 VDD VSS AOI21D2
XU15 n2978 n2977 n2979 VDD VSS AN2XD1
XU17 n2134 n1646 n2808 VDD VSS ND2D3
XU19 n2972 n2970 n2388 VDD VSS AN2D4
XU21 n1606 n1607 n1609 VDD VSS ND2D4
XU22 csa_sum_1[26] csa_carry_1[26] n2970 VDD VSS ND2D2
XU24 n2949 n2972 VDD VSS INVD2
XU25 n2886 n2888 VDD VSS INVD1
XU26 n3314 n3315 VDD VSS CKND2
XU27 csa_sum_1[25] csa_carry_1[25] n2645 VDD VSS ND2D2
XU28 n3500 n1479 VDD VSS INVD1
XU29 csa_sum_1[25] csa_carry_1[25] n2644 VDD VSS NR2XD3
XU30 csa_sum_1[22] csa_carry_1[22] n2885 VDD VSS ND2D4
XU31 csa_sum_1[22] csa_carry_1[22] n2883 VDD VSS NR2XD4
XU34 csa_sum_1[20] csa_carry_1[20] n1241 VDD VSS ND2D4
XU35 csa_sum_1[21] csa_carry_1[21] n2206 VDD VSS ND2D2
XU36 n3463 n2038 VDD VSS INVD1
XU37 n1021 n1020 VDD VSS INVD1
XU38 FE_RN_143 selected_delta_3[24] VDD VSS CKND2
XU39 csa_sum_1[18] csa_carry_1[18] n3453 VDD VSS NR2XD2
XU40 csa_carry_1[20] n1101 VDD VSS CKND3
XU41 csa_sum_1[18] csa_carry_1[18] n1298 VDD VSS ND2D4
XU42 n8 n2375 n1137 VDD VSS CKND2D8
XU43 csa_sum_1[13] csa_carry_1[13] n1359 VDD VSS ND2D4
XU44 csa_sum_1[13] csa_carry_1[13] n2049 VDD VSS NR2XD4
XU45 n3638 n640 n3849 VDD VSS INR2XD1
XU46 csa_sum_1[1] n1172 VDD VSS INVD1
XU48 n3717 n1436 n2334 VDD VSS INR2XD2
XU49 n397 n978 n977 VDD VSS ND2D4
XU50 n2026 n266 n2637 n2297 n1209 VDD VSS AOI211XD1
XU53 n3518 FE_OFN2803_n2600 n2231 VDD VSS ND2D3
XU54 csa_sum_1[5] csa_carry_1[5] n1150 VDD VSS CKND2D8
XU55 csa_sum_1[5] csa_carry_1[5] n3463 VDD VSS NR2XD2
XU56 n266 n3212 n718 VDD VSS ND2D2
XU57 n3724 n3719 VDD VSS BUFFD1
XU58 n3813 n1786 n3812 n492 VDD VSS ND3D2
XU59 n1948 n3703 n833 VDD VSS NR2XD2
XU60 n490 n3800 n491 VDD VSS ND2D1
XU61 n426 n1756 base_plane[18] VDD VSS ND2D4
XU62 n2636 n2635 n3212 VDD VSS CKND2D2
XU63 n1748 n1466 n3452 VDD VSS CKXOR2D1
XU64 n3724 n3717 VDD VSS BUFFD1
XU65 n2642 n2641 n2960 VDD VSS NR2XD1
XU66 n1786 n3812 n3813 n655 n654 VDD VSS AOI31D1
XU67 n3309 n3308 n3470 VDD VSS OR2D1
XU69 n3508 n1552 VDD VSS INVD1
XU71 csa_carry_1[3] n1024 VDD VSS CKND4
XU73 n1046 n3655 n1045 VDD VSS NR2D2
XU74 n2639 n2640 n2638 n2636 n2642 VDD VSS FA1D1
XU75 n1183 n1182 VDD VSS INVD2
XU76 n3712 n838 n3715 VDD VSS IND2D0
XU77 n1766 n1761 n220 VDD VSS AN2D4
XU78 n2634 n2635 VDD VSS INVD0
XU79 n3799 n3798 n3813 VDD VSS ND2D1
XU80 n1894 n1893 n3656 VDD VSS CKND2D2
XU81 n378 n3605 n3586 n1450 VDD VSS AOI21D4
XU82 n3673 n242 VDD VSS INVD2
XU83 n2621 n2620 n3655 VDD VSS ND2D2
XU84 FE_RN_119 n1200 n1754 VDD VSS CKND2D8
XU85 n3296 n1702 n973 VDD VSS ND2D2
XU87 n1160 n36 VDD VSS CKND2
XU88 n3752 n1900 VDD VSS INVD2
XU89 n3375 n38 VDD VSS INVD0
XU90 n40 n1899 base_plane[13] VDD VSS ND2D8
XU92 n804 n803 n1470 VDD VSS NR2D3
XU93 n2617 FE_OFN1361_n727 n2619 n2547 VDD VSS AOI21D4
XU95 n587 n586 n1789 VDD VSS ND2D4
XU97 n3701 n3698 n3702 n1329 VDD VSS OAI21D4
XU99 n2190 n3645 n2189 VDD VSS NR2XD2
XU100 n3646 n3643 n2190 VDD VSS INR2D2
XU101 n1981 n1702 VDD VSS INVD1
XU102 n3781 n270 VDD VSS CKND2
XU103 n3379 n2179 VDD VSS INVD2
XU104 n3613 n3225 VDD VSS CKND2
XU106 n3502 n1945 n620 VDD VSS IND2D2
XU107 n3587 n3604 n3588 n3697 VDD VSS OAI21D4
XU108 n3646 n3642 n2192 VDD VSS INR2D2
XU111 n3383 n3382 n1840 VDD VSS ND2D3
XU112 n3502 n3422 n1184 VDD VSS NR2XD1
XU113 n3804 n3801 n3818 VDD VSS NR2XD0
XU114 n3579 n3578 n3699 VDD VSS NR2XD1
XU116 n583 n582 n587 VDD VSS CKND2D4
XU118 n443 n441 n767 VDD VSS NR2D8
XU119 n1690 n2022 n247 n475 VDD VSS AOI21D4
XU120 n1533 n3653 n3609 VDD VSS ND2D8
XU121 n3381 n3383 VDD VSS INVD2
XU122 n3557 n1981 VDD VSS INVD1
XU123 n3339 n3042 VDD VSS INVD3
XU124 n3372 n2022 VDD VSS INVD1
XU125 n3336 n3043 VDD VSS INVD2
XU126 n3502 n271 VDD VSS CKND2
XU128 n2044 n2087 n1305 VDD VSS CKND2D8
XU129 n2348 n3653 n3608 VDD VSS ND2D3
XU130 n3506 n2363 n3422 VDD VSS CKND2D2
XU131 n1690 n1901 n580 VDD VSS CKND2D4
XU132 n1163 n1317 n1162 VDD VSS CKND2D2
XU133 n3119 n3118 n3604 VDD VSS ND2D2
XU134 n3509 n3446 n1779 VDD VSS NR2XD1
XU135 FE_OCPN1580_n3622 n1074 n1331 VDD VSS INR2XD1
XU136 n1564 n3286 n3287 n930 VDD VSS XNR3D4
XU137 n3598 n3599 n612 VDD VSS NR2D2
XU138 n1351 n3616 n1350 n1348 VDD VSS OAI21D4
XU140 n1263 n3117 n3382 VDD VSS ND2D3
XU142 n3062 n3061 n1722 VDD VSS ND2D1
XU143 n3543 n3347 VDD VSS INVD1
XU144 n3127 n737 VDD VSS CKND2
XU146 FE_RN_128 n3752 n999 VDD VSS ND2D2
XU147 n3662 selected_delta_2[3] VDD VSS CKND4
XU149 FE_OCPN1542_n3642 n1770 VDD VSS INVD2
XU150 n232 n1351 VDD VSS CKND4
XU151 FE_OFN3404_n3209 n282 n2363 VDD VSS ND2D2
XU152 n2351 n3553 n3554 VDD VSS ND2D2
XU153 n228 n83 n1774 VDD VSS ND2D4
XU154 n3119 n3118 n3585 VDD VSS NR2D3
XU155 FE_OCPN1438_n2342 n3627 n2224 VDD VSS CKND2D3
XU157 n2200 n3120 n3587 VDD VSS NR2D3
XU158 n247 n3374 n643 n3510 VDD VSS AOI21D4
XU160 n2639 n1565 VDD VSS INVD2
XU161 n3732 n666 n3731 base_plane[2] VDD VSS IOA21D4
XU162 n1793 n3431 n1568 VDD VSS CKXOR2D1
XU163 n3544 n876 n962 VDD VSS IND2D4
XU164 n2880 n3116 VDD VSS CKND3
XU165 n3616 n267 VDD VSS INVD4
XU166 n3373 n643 VDD VSS INVD2
XU167 n3751 n279 VDD VSS INVD2
XU168 n3370 n25 VDD VSS INVD2
XU169 n1106 n280 n440 VDD VSS ND2D4
XU170 n2527 n2528 n3652 VDD VSS ND2D2
XU171 n3335 n368 VDD VSS CKND2
XU172 n277 n879 VDD VSS INVD2
XU173 FE_PSN1653_n2353 n3544 n228 VDD VSS INR2D4
XU174 n3267 n183 n3273 VDD VSS INR2D1
XU175 n3062 n3061 n3713 VDD VSS ND2D1
XU177 n281 n282 n3512 VDD VSS ND2D3
XU178 n3443 n3511 VDD VSS INVD1
XU179 n3686 n780 n2175 VDD VSS NR2D3
XU180 n1371 n1042 n3602 VDD VSS ND2D3
XU181 n3261 n3262 n3287 VDD VSS CKXOR2D4
XU182 n2633 n2639 VDD VSS INVD1
XU183 n2415 n2414 n213 VDD VSS OR2D4
XU184 n2279 n2255 VDD VSS INVD4
XU186 n3687 n780 VDD VSS CKND2
XU190 n2811 n2810 n2314 VDD VSS AN2D4
XU192 n1674 n3427 n3426 n1793 VDD VSS OAI21D1
XU193 n3207 n3206 n3373 VDD VSS ND2D2
XU194 FE_RN_28 n110 n227 VDD VSS AN2XD1
XU195 n682 n2982 n70 VDD VSS ND2D2
XU197 n1874 n3336 n3752 VDD VSS NR2XD2
XU198 n1816 n2046 n3753 VDD VSS ND2D2
XU199 n644 n2035 n3374 VDD VSS CKND2D4
XU200 n3108 n3098 n3099 n1994 VDD VSS ND3D1
XU203 n3340 n3343 n1417 VDD VSS NR2D3
XU204 n3060 n3092 n3061 VDD VSS ND2D1
XU206 n1816 n3205 VDD VSS INVD2
XU207 n3207 n644 VDD VSS CKND2
XU208 n3708 n3562 VDD VSS CKND2
XU209 n2064 n1663 VDD VSS CKND2
XU210 n2498 n2396 n1232 n2412 VDD VSS MUX2D2
XU211 n3222 n285 VDD VSS CKND3
XU212 n2327 n3203 n1874 VDD VSS ND2D4
XU215 n1393 FE_RN_78 n2007 VDD VSS INR2D4
XU216 n3474 n287 VDD VSS INVD3
XU217 FE_OCPN1187_n1844 n855 n1358 VDD VSS INR2D2
XU218 n1393 n3664 n1344 VDD VSS ND2D2
XU220 n3636 n238 VDD VSS CKND6
XU221 n1846 n940 n939 VDD VSS ND2D1
XU222 n3797 n3768 FE_OFN2790_n3795 n1749 VDD VSS OAI21D2
XU223 n3618 n283 VDD VSS INVD2
XU224 n3203 n3336 n3341 VDD VSS INR2XD1
XU225 n2777 n2627 n2609 VDD VSS INR2D1
XU229 n724 n902 n901 VDD VSS CKND2D4
XU230 n2575 n1729 n3069 n2633 VDD VSS XOR3D1
XU233 FE_OFN1375_n3252 n2733 n2689 n3467 VDD VSS XNR3D2
XU234 n2873 n2872 n3474 VDD VSS NR2D2
XU235 n3064 n1572 n3708 VDD VSS CKXOR2D1
XU236 n3570 n3601 VDD VSS INVD3
XU237 n2591 n2627 VDD VSS INVD1
XU238 n2092 n2093 n724 VDD VSS ND2D4
XU239 n1168 n2462 n3629 VDD VSS CKND2D4
XU240 n884 n2463 n3631 VDD VSS NR2XD8
XU241 FE_OCPN1578_n2768 n3738 VDD VSS INVD4
XU242 n884 n2463 n3632 VDD VSS ND2D4
XU243 n592 n2293 n1522 VDD VSS ND2D3
XU244 n3214 n2339 n2306 VDD VSS AN2D4
XU245 n2872 n2873 n3475 VDD VSS CKND2D4
XU246 n2863 n2862 n3691 VDD VSS CKND2D4
XU247 FE_OCPN1264_n1249 n1016 n2683 VDD VSS ND2D3
XU248 n2800 n2801 n3670 VDD VSS CKND2D4
XU249 n3332 n3334 n902 VDD VSS NR2D3
XU251 n3086 n82 n3705 VDD VSS INR2D4
XU252 FE_OFN2726_n107 n1535 n2218 VDD VSS CKND2D2
XU255 FE_OFN55_level_0 n2736 n3615 VDD VSS CKAN2D1
XU256 n3533 n1496 VDD VSS INVD1
XU257 n2401 FE_OFN109_n251 n2185 VDD VSS XOR2D4
XU258 n1926 n2171 n3348 VDD VSS IND2D2
XU260 n2365 n949 VDD VSS CKND4
XU261 n3164 n3334 VDD VSS INVD2
XU264 n3259 FE_OFN104_n3401 n2789 FE_OFN2752_x_21 n1744 VDD VSS OA22D0
XU265 n3237 n1717 n2578 VDD VSS NR2XD1
XU266 n554 FE_OCPN1550_n1802 n553 VDD VSS ND2D3
XU267 n2169 n2165 n678 VDD VSS CKND2D4
XU268 n1371 n2256 VDD VSS CKND2
XU270 n2879 FE_OFN3485_n3071 n3097 n1988 VDD VSS ND3D2
XU271 n1155 n2650 n2564 VDD VSS CKND2D3
XU272 n3107 FE_OFN2726_n107 n2870 n2869 n2875 VDD VSS OAI211D4
XU273 n2581 n56 VDD VSS BUFFD1
XU274 n1908 n1909 n2093 VDD VSS NR2XD4
XU275 n2050 n3198 n649 VDD VSS CKND2D1
XU276 n3129 n2047 n2590 n2568 VDD VSS XNR3D1
XU279 n1028 n2759 VDD VSS CKND4
XU280 n2242 n2778 n214 VDD VSS AN2D4
XU281 FE_RN_154 n1394 VDD VSS INVD4
XU282 n2050 FE_OFN101_n3160 n3797 VDD VSS NR2D4
XU283 n1461 n3045 n3164 VDD VSS ND2D3
XU284 n241 n64 n2011 VDD VSS XNR2D1
XU285 n925 n1985 n1984 VDD VSS ND2D2
XU286 n2769 n1151 VDD VSS INVD2
XU287 n986 n985 n1392 VDD VSS INR2XD2
XU288 n2845 n1371 n2849 VDD VSS CKND2D4
XU290 n1746 n2804 n1364 VDD VSS NR2D4
XU291 n1703 n2149 n2870 VDD VSS ND2D2
XU292 n632 n2494 n2354 n10 VDD VSS ND3D3
XU295 n680 n679 n2165 VDD VSS ND2D4
XU296 n3082 n324 n3084 VDD VSS NR2XD1
XU297 n2282 n2283 n2448 n3320 VDD VSS OAI21D2
XU298 n2264 n1449 n683 VDD VSS CKND2D4
XU299 n2581 n508 VDD VSS BUFFD4
XU300 n846 n1353 n551 VDD VSS ND2D3
XU301 n2866 n2865 n3574 VDD VSS NR2XD3
XU302 n28 n1878 n1908 VDD VSS NR2D8
XU303 n2594 n2761 n3063 VDD VSS ND2D1
XU304 n1878 n3544 n2233 VDD VSS NR2XD4
XU305 n2430 n1409 n2242 VDD VSS INR2D2
XU306 n3548 n1910 VDD VSS INVD2
XU309 n541 n855 VDD VSS CKND6
XU311 n2050 FE_OFN101_n3160 n3163 n591 VDD VSS OAI21D2
XU312 n3748 n3555 VDD VSS CKND2
XU313 n922 FE_OCPN1469_n2792 n2810 VDD VSS IND2D4
XU314 n3040 n250 VDD VSS CKND2
XU315 n1473 n1456 VDD VSS CKND2
XU316 FE_OCPN1467_n1677 n2484 n3051 VDD VSS NR2XD3
XU317 n822 n3517 VDD VSS CKND2
XU319 n3162 n3179 n3411 VDD VSS INR2XD1
XU320 n2778 n1409 n638 VDD VSS IND2D4
XU321 n461 n460 n462 n1461 VDD VSS ND3D3
XU322 n1152 n1940 n2769 VDD VSS ND2D2
XU323 n2837 n94 n384 n2865 VDD VSS AOI21D2
XU324 n800 n801 n799 VDD VSS CKND2D4
XU325 n3049 FE_OCPN1234_n3581 n533 VDD VSS NR2D2
XU326 n1925 n2170 n1142 VDD VSS CKND2D3
XU327 n2265 n1715 n1449 VDD VSS CKND2D2
XU329 n1464 n1912 n2353 VDD VSS CKND2D8
XU330 n3047 n1063 VDD VSS CKND2
XU331 n1926 n3041 VDD VSS INVD2
XU332 n2651 n1155 VDD VSS INVD2
XU333 n1501 n1500 n1499 n1409 VDD VSS ND3D3
XU334 n2768 FE_OCPN1421_n1941 n1218 VDD VSS ND2D2
XU335 n122 n3081 n1571 VDD VSS CKND2D2
XU337 n2680 n1790 n2936 VDD VSS CKND2D4
XU338 n2482 n2136 n2135 VDD VSS IND2D1
XU339 n2650 n1154 VDD VSS INVD3
XU340 FE_RN_100 n3329 n393 VDD VSS CKND2D3
XU341 n3036 n3748 VDD VSS BUFFD1
XU343 n556 n2764 n2846 VDD VSS CKND2D3
XU344 FE_OFN2795_n1743 n1676 n2170 VDD VSS INR2XD0
XU346 n1084 n1081 n2133 VDD VSS ND2D4
XU347 n118 n119 VDD VSS INVD4
XU348 n975 n976 n798 VDD VSS ND2D4
XU349 n549 n1067 n548 VDD VSS AN2D4
XU350 n2351 n2352 n3037 VDD VSS ND2D4
XU351 n1727 FE_OFN2754_x_18 n1294 VDD VSS ND2D2
XU352 n2251 n1716 n2240 VDD VSS ND2D3
XU353 n3024 n468 n483 n3023 n461 VDD VSS OAI211D2
XU354 n184 n1675 n2601 VDD VSS NR2XD0
XU355 FE_OFN2741_x_11 n2535 n1524 n2536 VDD VSS NR3D3
XU356 n1700 n2852 n1805 VDD VSS CKND2D2
XU357 FE_OCPN1448_n3128 n822 VDD VSS BUFFD4
XU360 n929 n184 VDD VSS INVD2
XU361 n1928 n484 VDD VSS INVD3
XU362 FE_RN_36 n543 VDD VSS INVD4
XU363 n2195 n921 VDD VSS INVD2
XU364 n929 n185 VDD VSS INVD4
XU365 n2083 n686 VDD VSS INVD4
XU367 n62 n482 n229 VDD VSS AN2D4
XU368 n1939 n466 n908 VDD VSS ND2D2
XU370 FE_OFN2798_n3030 n1472 n1471 VDD VSS ND2D4
XU374 n1271 n1636 n3401 VDD VSS NR2XD0
XU375 n317 n123 n913 VDD VSS INR2D4
XU376 n3034 FE_OCPN1461_n113 n479 VDD VSS INR2XD1
XU377 n562 n2234 n3328 VDD VSS ND2D4
XU378 n835 n647 n2488 VDD VSS ND2D4
XU380 n168 n2788 n2251 VDD VSS INR2D2
XU381 n1811 n1809 n2448 VDD VSS CKND2D4
XU382 n2082 n73 n1060 VDD VSS INR2XD1
XU383 n2853 n240 n912 VDD VSS CKND2D2
XU384 n122 n3081 n82 VDD VSS CKND2D8
XU385 n2126 n2127 n2131 VDD VSS NR2D3
XU386 n3519 n91 VDD VSS INVD1
XU387 n118 n122 VDD VSS CKND8
XU389 n2173 n2940 VDD VSS INVD2
XU390 n2680 n1801 VDD VSS INVD4
XU391 n2205 n1985 VDD VSS INVD1
XU392 n2199 n544 VDD VSS INVD4
XU394 n2853 n252 VDD VSS CKND4
XU398 n1026 n136 VDD VSS CKND2
XU399 n2804 n2002 n1091 VDD VSS ND2D4
XU400 n989 n2320 n2731 VDD VSS CKND2D2
XU401 n687 n688 n73 VDD VSS ND2D3
XU405 n1149 n562 VDD VSS CKND8
XU408 n1812 FE_RN_151 n198 VDD VSS OR2D4
XU409 n1133 n1800 n781 VDD VSS CKND2D4
XU417 n2735 n1858 VDD VSS INVD2
XU418 n2115 n1333 n1780 VDD VSS IND2D4
XU420 n117 n2442 n2441 VDD VSS ND2D4
XU421 n2707 n2724 n1709 n2789 n2320 VDD VSS OA22D0
XU424 n2839 n1085 VDD VSS INVD3
XU425 n2679 n134 n1940 VDD VSS ND2D3
XU426 n2676 n1624 n2650 VDD VSS ND2D3
XU427 n1624 n2676 n1783 VDD VSS IND2D4
XU428 n674 n673 n1912 VDD VSS ND2D4
XU432 n2229 n1114 VDD VSS INVD3
XU433 n2485 FE_OFN3409_y_17 n1675 VDD VSS CKND2D1
XU434 n1173 n1174 n1175 n1876 VDD VSS ND3D8
XU435 n2461 n1004 n1032 VDD VSS INR2D2
XU436 n292 n2393 n3003 VDD VSS CKND2D2
XU437 n1022 n361 n290 n357 VDD VSS ND3D2
XU438 n3152 n1946 n3159 VDD VSS CKND2D2
XU439 n288 n2722 n608 VDD VSS ND2D3
XU440 n468 n201 FE_OFN2787_n3022 n355 VDD VSS ND3D4
XU441 n2727 n326 FE_OCPN3460_n2753 n2733 n2729 VDD VSS OAI22D4
XU443 n3275 n100 VDD VSS BUFFD4
XU444 y_mantissa[18] n57 VDD VSS BUFFD1
XU446 n1629 n1959 n1173 VDD VSS IND2D4
XU448 n3660 n288 VDD VSS INVD3
XU449 n1315 n2679 VDD VSS INVD6
XU450 n994 n105 VDD VSS CKND3
XU452 n327 n3033 n1946 VDD VSS AN2XD1
XU453 n303 n1500 n701 VDD VSS ND2D4
XU454 n3785 n240 VDD VSS CKND2
XU455 n2747 n1906 VDD VSS INVD4
XU461 n1586 n1585 n134 VDD VSS CKND2D8
XU462 n1958 n84 n1174 VDD VSS CKND2D4
XU463 n434 n432 n431 n2676 VDD VSS ND3D4
XU465 y_mantissa[18] n1687 VDD VSS CKBD2
XU467 n2144 n2031 n2030 VDD VSS CKND2D2
XU471 n257 n1821 n2252 VDD VSS CKND2D2
XU472 n1868 n261 n2229 VDD VSS NR2D8
XU474 n361 n290 n360 VDD VSS NR2D3
XU475 n3098 n2439 n2760 VDD VSS CKND2D4
XU476 n1501 n1499 n702 VDD VSS CKND2D4
XU477 n3660 n1444 n732 VDD VSS CKND2D4
XU478 FE_OFN3481_n59 n1688 n2228 VDD VSS ND2D3
XU479 n1611 n1629 n1463 VDD VSS ND2D3
XU480 n395 n3299 VDD VSS BUFFD2
XU481 n85 n65 n795 VDD VSS ND2D4
XU482 n2751 n1271 n2115 VDD VSS NR2D2
XU483 n2558 n2559 VDD VSS INVD4
XU484 n2449 n1638 n2704 n2762 VDD VSS MUX2ND4
XU485 FE_OFN108_n2450 n2295 n1254 VDD VSS CKND2D4
XU486 FE_OCPN3516_n3128 n303 VDD VSS CKND6
XU487 n1629 n2145 n2144 VDD VSS ND2D4
XU488 n1065 n1005 n1004 VDD VSS ND2D4
XU489 n1438 n2558 n3533 VDD VSS NR2D3
XU490 n1691 n600 n2906 n599 VDD VSS AOI21D4
XU491 n3153 n292 VDD VSS CKND2
XU493 n60 n2089 n2439 VDD VSS CKND2D4
XU498 n1710 n2852 VDD VSS CKND2
XU499 n80 n1868 VDD VSS INVD6
XU500 n1584 n2056 n1586 VDD VSS ND2D4
XU502 n309 n3530 n3535 VDD VSS CKND2D2
XU503 n97 n93 n980 VDD VSS INR2D1
XU504 n829 n237 n828 n3531 VDD VSS OAI21D4
XU505 n700 n1821 n1499 VDD VSS ND2D2
XU506 FE_OFN2804_y_13 n2476 n2275 VDD VSS INR2D2
XU507 n3139 n3138 n3145 VDD VSS NR2D1
XU508 n1494 n1495 FE_OFN3411_n2670 n1492 VDD VSS ND3D2
XU509 n2704 n981 n2750 VDD VSS XOR2D4
XU510 n2032 n2916 n2031 VDD VSS NR2XD0
XU511 n2063 n2787 n2152 VDD VSS ND2D4
XU513 n2090 n2091 n1959 VDD VSS NR2D1
XU515 n2704 n85 VDD VSS BUFFD8
XU516 n3428 n237 VDD VSS INVD4
XU518 n2156 n1821 VDD VSS CKND2
XU524 n3519 n1569 VDD VSS CKND4
XU527 FE_OFN107_n1696 n2390 n2071 VDD VSS NR2XD4
XU528 n257 n1273 VDD VSS CKND2
XU529 n3080 n118 VDD VSS INVD8
XU531 n3791 n2596 VDD VSS CKND2
XU532 n1224 n3530 VDD VSS CKND2
XU533 n161 n1634 n3139 VDD VSS NR2D2
XU534 FE_OCPN3441_n2086 n433 VDD VSS INVD1
XU536 n3094 n2063 VDD VSS INVD6
XU537 FE_OCPN3441_n2086 n436 n435 VDD VSS INR2D2
XU540 n1917 n1915 n3527 VDD VSS ND2D3
XU541 n2430 n257 VDD VSS INVD2
XU542 n2913 n2909 VDD VSS INVD4
XU543 n1898 n1164 n1914 VDD VSS ND2D8
XU544 n1691 n594 n1494 VDD VSS CKND2D3
XU546 n2930 n2156 VDD VSS INVD1
XU547 n1338 n1337 VDD VSS CKND4
XU548 n2172 n2091 VDD VSS INVD1
XU549 n1706 n1864 VDD VSS INVD4
XU550 FE_OFN2732_y_10 n2918 n1743 VDD VSS ND2D3
XU551 n1169 n2914 n2090 VDD VSS ND2D3
XU552 FE_OFN17_x_12 n2841 n2998 VDD VSS ND2D3
XU555 n765 n2082 n2019 VDD VSS ND2D4
XU557 FE_OFN1372_n2554 FE_OFN1368_n1686 n2556 VDD VSS ND2D3
XU558 n2912 n2987 n894 VDD VSS NR2D4
XU559 n3519 n3094 VDD VSS CKND12
XU560 n827 n2704 n3080 VDD VSS NR2D8
XU561 n2777 n2002 VDD VSS CKND6
XU563 n2898 n308 VDD VSS INVD4
XU564 n2394 n1204 VDD VSS INVD4
XU565 n2654 n2088 VDD VSS INVD2
XU566 n1758 n2455 n191 VDD VSS AN2D4
XU567 n1863 n338 n2738 n331 VDD VSS ND3D3
XU568 n1707 n629 n2988 VDD VSS CKND2D1
XU569 n2685 n2082 VDD VSS CKND2
XU570 n2930 FE_OFN98_n300 n1237 VDD VSS ND2D2
XU571 n51 n52 VDD VSS CKND2
XU572 n1760 n1968 n1164 VDD VSS NR2XD2
XU573 n139 FE_OFN1337_n1794 n1221 n2714 VDD VSS AOI21D4
XU574 n2905 n2904 n1964 VDD VSS CKND2D4
XU575 n1594 n1595 n1596 VDD VSS ND2D2
XU576 n395 n3519 VDD VSS BUFFD16
XU577 n774 n601 n2672 VDD VSS NR2XD1
XU579 n255 n101 n2917 VDD VSS NR2D3
XU581 n1049 n1048 VDD VSS CKND4
XU583 n2024 n2654 VDD VSS INVD1
XU584 n2992 n904 VDD VSS INVD2
XU587 n2894 n601 VDD VSS INVD2
XU589 n2653 n1595 VDD VSS CKND2
XU591 n3106 n2590 VDD VSS CKND2
XU592 n1223 n139 VDD VSS CKBD4
XU598 n2893 n774 VDD VSS BUFFD2
XU601 n1302 n1966 VDD VSS CKND6
XU602 x_mantissa[6] n472 n2904 VDD VSS ND2D2
XU603 n101 n255 n2920 VDD VSS ND2D4
XU604 n2418 n1707 n2987 VDD VSS NR2D3
XU605 n319 n1515 n3011 VDD VSS NR2D2
XU606 n1696 n465 n2403 VDD VSS NR2XD2
XU608 n2930 y_mantissa[12] n2991 VDD VSS NR2XD2
XU612 n1668 n2992 n1696 VDD VSS CKND2D4
XU616 n2452 n58 VDD VSS BUFFD8
XU617 n2094 n961 VDD VSS INVD4
XU619 n1515 n2786 VDD VSS INVD1
XU620 n74 n2475 n1863 VDD VSS ND2D8
XU622 n1628 n2077 n1064 VDD VSS CKND2D8
XU623 FE_OCPN3519_n3128 n2436 VDD VSS CKND16
XU625 FE_OFN1336_n375 n2660 VDD VSS CKND6
XU627 n3275 n348 VDD VSS CKND12
XU631 n395 n3275 VDD VSS BUFFD16
XU633 n2655 n2443 n409 VDD VSS INR2XD2
XU635 FE_RN_141 n1251 n1543 VDD VSS IND2D4
XU638 y_mantissa[14] n1515 VDD VSS BUFFD2
XU641 n2667 n2024 n2898 VDD VSS CKND2D8
XU642 n98 n2907 n2094 VDD VSS NR2D8
XU643 n1640 FE_OFN1366_n1641 n1300 VDD VSS ND2D4
XU644 n2077 n164 n1668 n2076 VDD VSS AN3D4
XU646 n165 n166 n2021 VDD VSS CKND2D4
XU647 n2075 FE_OFN3500_n2719 n2443 VDD VSS ND2D4
XU650 n164 FE_OCPN1545_n402 n2434 VDD VSS CKND2D8
XU652 n1411 n1519 n2895 VDD VSS ND2D8
XU653 n2452 n395 VDD VSS BUFFD16
XU654 n2435 n2901 n2896 VDD VSS ND2D4
XU655 y_mantissa[4] FE_RN_210_0 n1462 VDD VSS NR2XD4
XU656 n109 y_mantissa[9] n1668 VDD VSS NR2XD4
XU658 n137 n138 VDD VSS CKND8
XU659 n1321 n164 VDD VSS CKND8
XU660 x_mantissa[1] n137 VDD VSS INVD6
XU667 n772 n557 VDD VSS INVD2
XU668 n3376 n3463 n2284 VDD VSS NR2XD4
XU671 n1479 FE_OCPN1167_n669 n3501 VDD VSS ND2D2
XU672 n945 n3320 n944 VDD VSS CKND2D3
XU675 n863 n862 n3520 VDD VSS NR2D8
XU676 n2811 FE_OCPN1187_n1844 n856 VDD VSS CKND2D4
XU677 n3630 n3631 n2464 VDD VSS NR2XD3
XU678 n1132 n781 n820 VDD VSS ND2D3
XU679 n60 n2076 n373 VDD VSS ND2D4
XU680 n1773 n1808 n2851 VDD VSS ND2D4
XU683 n4 n204 VDD VSS CKND4
XU684 n1360 n3251 n4 VDD VSS CKND2D4
XU685 n299 n2157 selected_delta_3[9] VDD VSS INR2XD2
XU686 n2012 n2482 n194 n1134 VDD VSS AOI21D4
XU687 n2191 n2189 n2188 VDD VSS CKND2D4
XU688 n726 n2164 n942 VDD VSS ND2D4
XU689 n887 FE_OCPN3468_n n2072 VDD VSS NR2D8
XU693 n2888 FE_OCPN1401_n2887 n2889 VDD VSS ND2D2
XU694 n41 n147 shared_plane[24] VDD VSS ND2D4
XU696 n392 n860 n741 VDD VSS ND2D8
XU698 n115 n292 n363 VDD VSS CKND2D4
XU700 n116 n2290 n2013 VDD VSS ND2D4
XU702 FE_OCPN1462_n3347 n1305 n791 n584 n586 VDD VSS OAI211D4
XU703 csa_sum_1[4] csa_carry_1[4] n2966 VDD VSS NR2D8
XU704 n88 n6 n722 VDD VSS ND2D2
XU705 n747 n3541 n6 VDD VSS AN2XD1
XU706 FE_OCPN1434_n2092 n2093 n88 VDD VSS CKND2D4
XU707 n1145 n2306 n761 VDD VSS ND2D3
XU708 n3745 FE_OCPN1607_n2339 n3544 VDD VSS ND2D4
XU710 n429 n3752 n19 VDD VSS ND2D4
XU711 n2087 n2044 n429 VDD VSS ND2D8
XU712 n1065 n2460 n175 VDD VSS ND2D4
XU714 n971 n979 n390 VDD VSS ND2D4
XU717 n7 n2155 n1613 VDD VSS ND2D8
XU719 n350 n851 VDD VSS INVD6
XU721 n2055 n2323 n2928 n673 VDD VSS ND3D2
XU722 n347 n1099 n80 VDD VSS ND2D8
XU723 n235 FE_RN_134 n2352 VDD VSS CKND2D8
XU726 n409 n1792 n809 VDD VSS ND2D4
XU727 n378 n3606 n1980 VDD VSS XNR2D4
XU728 n1905 n2118 n445 VDD VSS ND2D4
XU729 n1905 n2118 n157 VDD VSS ND2D2
XU730 n2381 n2244 VDD VSS INVD2
XU731 n1613 n947 n946 VDD VSS CKND2D8
XU733 n1201 n1200 n727 VDD VSS ND2D4
XU734 n3548 n2353 n1878 VDD VSS CKND2D8
XU735 n362 n1928 n3548 VDD VSS ND2D4
XU736 n3037 n3550 n524 VDD VSS NR2XD3
XU737 n579 n145 VDD VSS INVD4
XU738 n1312 n1311 n579 VDD VSS ND2D4
XU739 n377 n1637 n771 VDD VSS ND2D8
XU741 n621 n620 n1615 n22 VDD VSS ND3D2
XU742 n114 n1186 n1240 VDD VSS CKND2D4
XU743 n1816 n3204 n1857 VDD VSS NR2D3
XU744 n2781 n295 VDD VSS INVD8
XU745 n1870 n1582 VDD VSS INVD2
XU746 n1314 n428 n13 VDD VSS NR2D3
XU747 n1929 n2678 n428 VDD VSS ND2D3
XU748 FE_OFN2721_n2296 n1848 n2781 VDD VSS ND2D8
XU749 n2675 n2678 n3733 VDD VSS NR2D8
XU751 csa_sum_1[17] n8 VDD VSS CKND4
XU753 n967 n1266 VDD VSS CKND2
XU757 n545 n1030 n1590 VDD VSS ND2D8
XU759 n391 n2269 n766 VDD VSS CKND2D8
XU760 n175 n295 n419 VDD VSS ND2D4
XU763 FE_RN_96 n2348 n3651 n32 VDD VSS AOI21D4
XU764 n10 n635 n631 VDD VSS NR2XD3
XU768 n1313 n2952 n12 VDD VSS ND2D4
XU770 n3444 n3442 n3418 VDD VSS NR2XD1
XU771 n3418 n3506 VDD VSS INVD2
XU772 n1473 n2050 VDD VSS CKND4
XU773 FE_PSN1626_n1507 FE_OCPN1479_FE_RN_4 n1201 VDD VSS ND2D8
XU774 FE_RN_64 n213 n278 n1328 VDD VSS AOI21D4
XU775 n380 n769 n768 VDD VSS ND2D8
XU777 csa_carry_1[8] n1030 VDD VSS INVD6
XU778 n847 n2791 n1357 VDD VSS CKND2D4
XU779 n1058 n1057 n1386 VDD VSS ND2D4
XU780 n398 n2810 n1859 VDD VSS CKND2D4
XU782 FE_OFN1362_n766 FE_OFN3487_n3408 n853 VDD VSS ND2D4
XU783 n1266 n2648 n810 VDD VSS ND2D2
XU785 n1036 n624 n380 VDD VSS CKND2D8
XU786 n545 n1030 n1539 VDD VSS CKND2D4
XU787 n1540 n1539 n2367 VDD VSS ND2D4
XU788 n381 FE_OCPN3458_n3475 n209 n775 VDD VSS AOI21D4
XU789 n104 n287 n381 VDD VSS ND2D4
XU790 n1285 n1669 n1284 VDD VSS ND2D3
XU791 csa_sum_1[16] csa_carry_1[16] n3357 VDD VSS ND2D4
XU792 csa_sum_1[16] csa_carry_1[16] n3356 VDD VSS NR2XD4
XU793 n1036 n1352 n1070 VDD VSS ND2D8
XU794 n1047 n2117 n1540 VDD VSS ND2D3
XU795 FE_RN_6 FE_RN_142 n2450 VDD VSS NR2XD8
XU796 n555 n2152 n1056 VDD VSS ND2D4
XU798 n2847 n1028 n1355 VDD VSS NR2D4
XU799 csa_sum_1[6] csa_carry_1[6] n3376 VDD VSS NR2XD4
XU801 n1007 n2074 n2178 n1755 VDD VSS AOI21D4
XU802 n579 n153 n147 VDD VSS CKND2D4
XU803 n3477 n3478 shared_plane[15] VDD VSS XOR2D4
XU806 n14 n549 n740 VDD VSS ND2D8
XU808 FE_RN_14 n2808 shared_plane[22] VDD VSS XNR2D4
XU810 n1386 n215 n1036 VDD VSS CKND2D8
XU811 csa_sum_1[12] n397 VDD VSS CKND4
XU812 FE_RN_4 n2192 n2191 VDD VSS ND2D4
XU813 csa_sum_1[8] n545 VDD VSS INVD6
XU817 FE_OCPN3517_n3128 n3831 VDD VSS CKND16
XU821 n3292 n2341 n444 VDD VSS ND2D2
XU823 n295 FE_OFN2795_n1743 n2814 VDD VSS CKND2D2
XU825 csa_sum_1[15] csa_carry_1[15] n566 VDD VSS ND2D4
XU826 n16 n3553 n1882 VDD VSS CKND2D2
XU827 n670 n2351 n16 VDD VSS ND2D2
XU828 n452 n580 FE_OCPN1597_n3510 n1814 VDD VSS ND3D2
XU829 n3211 n3517 n2042 VDD VSS ND2D3
XU830 FE_RN_61 n2087 VDD VSS CKND8
XU834 n734 n2974 n1285 VDD VSS ND2D2
XU835 FE_RN_18 n1310 n734 VDD VSS ND2D2
XU836 n526 n3744 n2085 VDD VSS ND2D8
XU838 n205 n151 n377 VDD VSS CKND2D8
XU839 n536 n547 n863 VDD VSS ND2D4
XU844 n1478 FE_OCPN1167_n669 n3493 VDD VSS CKND2D4
XU845 n1284 n1283 shared_plane[27] VDD VSS ND2D4
XU847 n61 n2394 n251 VDD VSS ND2D3
XU848 n943 n946 n882 VDD VSS ND2D8
XU849 n2884 FE_RN_99 n725 VDD VSS CKND2D4
XU850 n2555 FE_OCPN1172_n668 n1759 n2333 VDD VSS AO21D1
XU851 FE_RN_138 n453 VDD VSS CKND4
XU853 n19 n20 n18 VDD VSS ND2D4
XU854 n1871 n20 VDD VSS CKND2
XU855 n2338 n21 n455 VDD VSS ND2D4
XU857 n2939 n2173 n2338 VDD VSS CKND2D4
XU859 y_mantissa[1] FE_OCPN8_y_0 n2554 VDD VSS CKND2D4
XU863 n3681 n2984 n3682 VDD VSS ND2D2
XU864 n2969 n2387 VDD VSS INVD2
XU865 n168 n175 n2120 VDD VSS INR2D4
XU866 n148 n958 n2039 VDD VSS ND2D8
XU868 n1538 n3831 n391 VDD VSS ND2D4
XU872 n354 n1453 n1452 VDD VSS ND2D4
XU874 FE_OFN65_n378 n1950 n1949 VDD VSS CKND2D4
XU875 n2387 n1008 n2388 n2386 n1605 VDD VSS OAI211D2
XU879 n22 n3202 n1238 VDD VSS CKXOR2D1
XU880 n1674 n2201 n3180 n518 VDD VSS OAI21D4
XU882 n496 FE_OFN1367_n1643 n495 VDD VSS ND2D2
XU883 FE_OCPN1225_n2718 y_mantissa[1] n2040 VDD VSS ND2D4
XU884 FE_RN_127 n488 n1778 VDD VSS CKND2D4
XU885 n23 n1547 n3508 VDD VSS NR2D2
XU886 n3504 n264 n1549 n23 VDD VSS OAI21D2
XU887 n3207 n26 VDD VSS INVD2
XU888 n24 n3451 base_plane[21] VDD VSS ND2D4
XU889 n3452 FE_OFN2803_n2600 n24 VDD VSS ND2D2
XU891 n279 n2364 n25 n1615 VDD VSS AOI21D4
XU892 n26 n3206 n3370 VDD VSS ND2D2
XU893 n3797 n3183 n3182 n43 VDD VSS OAI21D4
XU894 n429 FE_OCPN1475_n2349 n583 VDD VSS CKND2D4
XU895 n652 n1786 n230 VDD VSS AN2D2
XU896 n1550 n3503 n1549 VDD VSS NR2XD1
XU897 n27 n1971 n1245 VDD VSS ND2D2
XU899 n1019 n28 VDD VSS INVD4
XU900 n1877 n3214 n1019 VDD VSS ND2D4
XU904 n1126 n1125 n2785 VDD VSS CKND2D4
XU905 n1275 n1656 n1001 VDD VSS ND2D4
XU906 n2980 n685 VDD VSS CKND4
XU907 n3230 selected_delta_3[16] VDD VSS CKND4
XU908 n2366 n824 VDD VSS CKND4
XU909 n2171 n1926 n2366 VDD VSS ND2D4
XU912 n550 n3319 n945 VDD VSS CKND2D3
XU913 FE_OFN2732_y_10 FE_RN_39 n371 VDD VSS NR2XD4
XU914 n3093 n3283 VDD VSS INVD4
XU915 n3284 n30 n3093 VDD VSS CKXOR2D4
XU918 n2949 n2976 n2951 VDD VSS NR2XD2
XU919 FE_RN_18 n578 n1313 VDD VSS CKND2D4
XU920 n1927 n1430 n744 VDD VSS ND2D4
XU921 n1206 n1205 VDD VSS CKND3
XU922 n1997 n3697 n212 VDD VSS AN2XD1
XU923 FE_RN_120 n2886 n2385 VDD VSS NR2XD4
XU924 n341 n31 n605 VDD VSS CKND2D4
XU925 n2619 n2618 n425 n31 VDD VSS AOI21D4
XU928 n2490 n182 n2489 n2488 n107 VDD VSS OAI211D4
XU929 n3652 n3649 n1533 VDD VSS CKND2D4
XU930 FE_OFN106_n1673 n2071 n647 VDD VSS CKND2D8
XU933 n2945 n1208 VDD VSS CKND4
XU934 FE_OFN2726_n107 FE_OFN3427_n2438 n2521 VDD VSS CKXOR2D1
XU937 n1330 FE_OFN65_n378 n1995 VDD VSS ND2D8
XU939 n36 n34 n405 base_plane[12] VDD VSS OAI21D4
XU940 n37 n3517 n426 VDD VSS CKND2D3
XU942 n1452 n1451 n378 VDD VSS ND2D8
XU943 n2967 n2966 n883 n1477 VDD VSS OAI21D4
XU944 n3498 FE_RN_40 n1023 n2967 VDD VSS AOI21D4
XU947 FE_RN_28 n1145 n3746 VDD VSS ND2D2
XU949 n1276 n2911 n1000 VDD VSS ND2D2
XU950 n455 n454 n3551 VDD VSS CKND2D4
XU951 n2155 FE_OCPN1263_n942 n3389 VDD VSS ND2D2
XU952 n280 FE_PSN1628_n2352 n3552 VDD VSS ND2D4
XU955 FE_RN_84 n2256 n1042 n2064 VDD VSS OAI21D2
XU957 n3582 n2119 n3840 VDD VSS INR2XD2
XU958 n295 n2931 n2798 VDD VSS CKND2D3
XU960 FE_OFN66_n382 n3596 n3392 n2080 VDD VSS AOI21D4
XU961 n401 n90 n40 VDD VSS ND2D4
XU962 n145 n146 n41 VDD VSS ND2D4
XU964 n996 FE_OFN1367_n1643 n3778 VDD VSS CKND2D4
XU965 n1774 n3546 n815 VDD VSS ND2D2
XU966 n2929 n116 n2055 VDD VSS IND2D4
XU967 n2884 n2385 n1312 VDD VSS CKND2D4
XU968 n999 n998 VDD VSS INVD4
XU970 n1555 n1554 n3518 VDD VSS ND2D2
XU971 n550 n2342 n792 VDD VSS ND2D3
XU974 n3066 n45 VDD VSS INVD2
XU975 n3066 n46 VDD VSS INVD1
XU978 n3833 n49 VDD VSS INVD0
XU979 n49 n50 VDD VSS INVD0
XU980 n3834 n3833 VDD VSS INVD0
XU981 n3094 n256 VDD VSS CKND2
XU982 n2786 n51 VDD VSS INVD0
XU985 n3834 n3837 VDD VSS INVD0
XU986 y_mantissa[18] n3238 VDD VSS CKBD1
XU987 n2452 n2475 VDD VSS BUFFD8
XU988 n3810 n3052 VDD VSS INVD4
XU990 n114 n62 VDD VSS INVD6
XU993 n3073 n64 VDD VSS INVD1
XU1001 n682 n2982 n3663 VDD VSS CKND2D4
XU1002 n1727 n71 VDD VSS INVD4
XU1003 n71 n72 VDD VSS INVD3
XU1004 n713 n712 n3843 VDD VSS NR2D4
XU1007 n429 n1895 VDD VSS INVD4
XU1008 n3355 n75 VDD VSS INVD2
XU1009 FE_PSN1636_n566 n3355 VDD VSS CKND2
XU1010 n3512 n3510 n1897 VDD VSS INR2XD1
XU1012 n3682 selected_delta_2[24] VDD VSS INVD2
XU1013 n412 n2332 n1491 VDD VSS ND2D4
XU1014 n1528 n2809 mantissa_value[22] VDD VSS ND2D8
XU1015 n592 n2293 n3342 VDD VSS IND2D2
XU1016 n2327 n3342 n3343 VDD VSS ND2D2
XU1019 FE_RN_12 n59 n1689 n105 n155 VDD VSS OA22D4
XU1020 FE_OCPN1460_n2094 n1638 n2420 VDD VSS ND2D4
XU1022 n2732 n175 n2199 VDD VSS XNR2D4
XU1023 n2938 n1775 VDD VSS INVD6
XU1024 n2339 n2938 n1876 n1877 VDD VSS ND3D4
XU1025 n1775 n1166 n3745 VDD VSS ND2D4
XU1026 FE_OCPN12_n239 n102 n77 VDD VSS ND2D4
XU1027 n2644 n1474 n2645 n2973 VDD VSS OAI21D4
XU1028 FE_RN_12 n1569 n555 VDD VSS CKND2D4
XU1029 n982 n1069 n160 VDD VSS AN2D4
XU1030 FE_OCPN1327_n1069 n2728 VDD VSS CKND2
XU1031 FE_RN_69 n2087 n1487 VDD VSS ND2D8
XU1032 FE_OCPN1395_n1106 n524 n2044 VDD VSS ND2D8
XU1035 n2533 n3609 n1198 n3227 n2619 VDD VSS OAI211D4
XU1036 n929 n182 VDD VSS CKND8
XU1037 n79 n539 n346 VDD VSS INR2D4
XU1038 n2016 n1570 n2748 n79 VDD VSS OAI21D2
XU1039 n2749 n805 VDD VSS CKND2
XU1040 n347 n1099 n81 VDD VSS ND2D4
XU1041 n347 n1099 n2749 VDD VSS CKND2D4
XU1042 n563 n561 n83 VDD VSS ND2D4
XU1043 n563 n561 n876 VDD VSS CKND2D8
XU1044 n1914 FE_RN_53 n84 VDD VSS ND2D3
XU1045 FE_OCPN1490_n1914 n1913 n1022 VDD VSS ND2D8
XU1047 n2233 n876 n2092 VDD VSS ND2D8
XU1048 n3073 n93 VDD VSS INVD2
XU1049 FE_OCPN3456_FE_RN_41 n89 VDD VSS INVD1
XU1050 n89 n90 VDD VSS INVD2
XU1052 n101 n2455 VDD VSS INVD8
XU1053 n3073 n94 VDD VSS INVD1
XU1054 n3073 n95 VDD VSS INVD1
XU1061 n1299 n1795 n104 VDD VSS ND2D8
XU1064 n1998 shared_plane[1] VDD VSS INVD8
XU1067 n860 FE_RN_58 n117 VDD VSS ND2D4
XU1069 n810 n1265 shared_plane[25] VDD VSS CKND2D4
XU1070 n118 n120 VDD VSS CKND6
XU1071 n118 n121 VDD VSS INVD8
XU1072 n1218 FE_OCPN1420_n428 n2770 VDD VSS ND2D2
XU1073 n2675 n1942 n1941 VDD VSS CKND2D4
XU1077 FE_RN_134 n1304 n1911 VDD VSS IND2D4
XU1078 n2558 n1438 n3534 VDD VSS ND2D3
XU1079 n1560 n3743 n1602 VDD VSS ND2D4
XU1080 n962 n3545 n2932 VDD VSS ND2D4
XU1081 n342 n125 n126 VDD VSS ND2D2
XU1082 n124 n3624 n127 VDD VSS ND2D2
XU1083 n126 n127 n2193 VDD VSS CKND2D3
XU1084 n342 n124 VDD VSS INVD2
XU1085 n3624 n125 VDD VSS INVD1
XU1086 FE_RN_74 FE_OCPN1569_n1066 n198 n128 VDD VSS AOI21D2
XU1087 FE_RN_74 FE_OCPN1437_n1066 n198 n129 VDD VSS AOI21D2
XU1088 FE_RN_74 n1066 n198 n3319 VDD VSS AOI21D4
XU1091 n338 n1863 n132 VDD VSS ND2D4
XU1094 n977 n3485 n2372 VDD VSS CKND2D4
XU1095 FE_RN_20 n1068 n2371 VDD VSS ND2D4
XU1096 n3744 FE_OCPN1414_n3329 n842 VDD VSS ND2D4
XU1097 FE_RN_126 FE_RN_22 n1130 VDD VSS ND2D4
XU1098 n3727 n3726 n1617 n1440 VDD VSS AOI21D4
XU1100 n2553 n1226 n1224 VDD VSS CKND2D2
XU1101 FE_OCPN1476_FE_OFN1126_x_0 n138 n1226 VDD VSS ND2D3
XU1103 n3537 n302 n3538 VDD VSS ND2D2
XU1104 n761 n110 n757 n756 VDD VSS IND3D2
XU1105 n1440 n789 VDD VSS INVD2
XU1106 n3454 n135 VDD VSS CKND2
XU1107 FE_OCPN1430_n1298 n3454 VDD VSS CKND2
XU1108 FE_OCPN1456_FE_RN_25 n1965 VDD VSS INVD4
XU1109 FE_OFN1365_n1053 n2753 n617 VDD VSS IND2D4
XU1110 n917 n1026 VDD VSS INVD3
XU1111 n1661 FE_OCPN1551_n3733 FE_OCPN3465_n3734 n1153 VDD VSS OAI21D4
XU1112 n1223 n96 n2493 VDD VSS AN2D2
XU1113 n2698 n3695 n2305 VDD VSS AN2D4
XU1115 n1130 n1315 n1012 VDD VSS CKND2D4
XU1116 n1898 n2440 n1250 n2662 VDD VSS AOI21D4
XU1117 n2000 n2987 n2023 VDD VSS NR2D2
XU1118 n2913 n2000 n893 VDD VSS NR2D4
XU1119 n517 n3168 n3204 VDD VSS CKXOR2D4
XU1120 n684 n683 n1255 VDD VSS ND2D4
XU1121 n2559 n1438 n1229 VDD VSS CKND2D3
XU1122 csa_sum_1[7] n866 VDD VSS INVD6
XU1124 n128 n3627 VDD VSS INVD2
XU1125 n3739 n305 n3740 VDD VSS ND2D2
XU1126 n2746 n2710 VDD VSS CKND4
XU1127 n333 n332 n2687 VDD VSS ND2D4
XU1128 n556 n2764 n2847 VDD VSS NR2D8
XU1129 FE_OFN1349_FE_RN_56 FE_OCPN1305_n1620 FE_OCPN1294_n2744 n140 VDD VSS
+ OAI21D4
XU1131 n2493 n2309 n2497 n635 VDD VSS ND3D4
XU1132 FE_OCPN1175_n1053 n619 n618 VDD VSS ND2D4
XU1135 n1869 FE_OCPN1217_n2747 n3583 VDD VSS ND2D4
XU1136 n2885 n2886 n2887 n2384 VDD VSS OAI21D4
XU1137 n2838 n2399 n3081 VDD VSS INR2XD4
XU1138 n3288 FE_OFN2744_y_20 n2500 n2539 VDD VSS OAI21D4
XU1139 n1434 n82 n1433 n1431 n3126 VDD VSS OAI211D4
XU1140 n2695 n2553 VDD VSS INVD6
XU1141 n802 n142 n143 VDD VSS ND2D2
XU1143 n802 n141 VDD VSS INVD2
XU1144 n2314 n142 VDD VSS CKND2
XU1145 n153 n146 VDD VSS INVD2
XU1146 n2039 n1358 FE_OCPN1190_n1357 n802 VDD VSS AOI21D4
XU1147 FE_OCPN1218_n550 n3320 n2302 VDD VSS AN2D4
XU1148 n708 n160 n1335 VDD VSS ND2D4
XU1153 n1640 n138 n1111 VDD VSS ND2D3
XU1154 n2695 n1050 n974 VDD VSS ND2D8
XU1155 shared_plane[14] divided_plane[14] n3836 mantissa_value[14] VDD VSS
+ MUX2D2
XU1156 y_mantissa[11] n2930 VDD VSS BUFFD4
XU1157 n255 y_mantissa[11] n2992 VDD VSS NR2XD3
XU1158 divide_mode n3128 VDD VSS INVD12
XU1159 divide_mode n2452 VDD VSS INVD8
XU1160 n69 n2780 n3005 VDD VSS ND2D1
XU1161 FE_OCPN3461_FE_OFN16_x_12 n629 n2000 VDD VSS NR2D8
XU1164 x_mantissa[0] FE_RN_141 n1301 VDD VSS IND2D4
XU1166 n1305 n3043 n3042 n571 VDD VSS AOI21D4
XU1169 n1604 n1605 shared_plane[26] VDD VSS ND2D4
XU1170 n699 n2021 n1854 VDD VSS NR2D4
XU1171 FE_RN_59 n1854 FE_RN_149 n392 VDD VSS AOI21D4
XU1172 FE_RN_54 FE_RN_41 n151 VDD VSS CKND2D8
XU1173 n86 FE_OCPN1324_FE_OFN74_n2653 n436 n431 VDD VSS ND3D2
XU1174 n2653 n86 n435 n434 VDD VSS IOA21D2
XU1175 n2653 n914 n826 VDD VSS ND2D3
XU1176 n2038 n76 n2037 VDD VSS ND2D3
XU1177 csa_sum_1[4] csa_carry_1[4] n883 VDD VSS CKND2D8
XU1178 n396 n1799 n152 VDD VSS ND2D8
XU1179 n396 n1799 n874 VDD VSS ND2D4
XU1180 n3315 n1474 n153 VDD VSS ND2D2
XU1181 n1523 n2758 n1028 VDD VSS CKND2D4
XU1182 csa_carry_1[8] FE_OCPN1245_csa_sum_1_8 n154 VDD VSS ND2D1
XU1183 n1008 n2387 n2386 n156 VDD VSS OAI21D2
XU1189 n351 n379 n2281 VDD VSS ND2D4
XU1190 n353 n352 n351 VDD VSS ND2D4
XU1191 n3224 n2281 n3842 VDD VSS INR2D4
XU1193 n161 n69 n3006 VDD VSS ND2D1
XU1194 n161 n1634 n3141 VDD VSS ND2D1
XU1195 n1399 n3008 n196 VDD VSS XNR2D1
XU1197 shared_plane[15] n162 VDD VSS INVD8
XU1198 shared_plane[15] n163 VDD VSS INVD0
XU1199 n1321 n165 VDD VSS INVD4
XU1200 n2077 n164 n1591 VDD VSS ND2D8
XU1201 n1321 n1628 VDD VSS INVD6
XU1202 FE_OCPN1_y_4 n2708 n1321 VDD VSS ND2D8
XU1204 n166 n1698 n2667 VDD VSS ND2D4
XU1206 n2452 n2715 VDD VSS BUFFD4
XU1213 FE_OCPN1247_shared_plane_27 n172 VDD VSS INVD0
XU1214 n172 n173 VDD VSS INVD0
XU1215 n1113 n117 n1307 VDD VSS ND2D2
XU1216 n602 n174 VDD VSS INVD1
XU1217 n82 n3150 n418 VDD VSS NR2XD2
XU1218 n1571 n3166 n1146 VDD VSS ND2D1
XU1219 FE_OCPN1302_n917 n2575 n975 VDD VSS CKND2D4
XU1220 n1065 n2460 n917 VDD VSS ND2D4
XU1221 FE_OCPN1525_n1616 FE_OCPN1143_n3459 n177 VDD VSS CKXOR2D1
XU1222 n3832 FE_OCPN1165_n178 n2891 VDD VSS CKND2D1
XU1223 n1608 FE_OCPN1157_n1609 n179 VDD VSS CKND2D0
XU1224 n1122 n1121 n180 VDD VSS ND2D8
XU1225 n1122 n1121 n181 VDD VSS ND2D4
XU1226 n1122 n1121 n1684 VDD VSS ND2D2
XU1227 n1677 n929 VDD VSS INVD8
XU1228 n929 n183 VDD VSS INVD4
XU1229 n183 n1675 n1687 n2106 VDD VSS OAI21D4
XU1230 n187 n1700 n1782 VDD VSS NR2XD4
XU1231 n1178 FE_RN_145 n186 n1176 VDD VSS OAI21D4
XU1233 n1170 n188 VDD VSS INVD4
XU1234 n121 n2926 n1011 VDD VSS CKND2D4
XU1235 n1170 n189 VDD VSS INVD4
XU1236 n1740 n827 VDD VSS INVD2
XU1237 n121 n1170 VDD VSS INVD8
XU1238 n3789 n3788 n3787 n3790 VDD VSS OA21D0
XU1240 n2957 n2960 n2958 VDD VSS NR2D0
XU1242 n471 n1250 VDD VSS INVD2
XU1243 n3186 n367 VDD VSS INVD2
XU1245 n3676 n3675 n3677 VDD VSS ND2D1
XU1246 n3721 n3564 VDD VSS INVD0
XU1247 n3052 n2455 n1179 VDD VSS ND2D8
XU1248 n2909 n2172 n2908 VDD VSS ND2D1
XU1249 n2054 n2053 VDD VSS CKND2
XU1251 n239 n241 FE_OCPN1560_n395 n1003 n3277 VDD VSS AOI22D4
XU1253 n799 n2043 VDD VSS CKND2
XU1254 FE_RN_62 n757 VDD VSS CKND2
XU1255 n1719 n254 n1052 n2754 VDD VSS IOA21D4
XU1256 n799 n2793 n684 VDD VSS NR2XD4
XU1257 n676 n984 n3667 VDD VSS ND2D3
XU1259 n249 n1945 n279 n576 VDD VSS AOI21D2
XU1260 FE_OCPN1444_n2475 FE_OCPN1172_n668 n2692 VDD VSS ND2D4
XU1261 FE_OCPN3444_n2980 n275 n1363 VDD VSS ND2D4
XU1262 n1829 n1830 VDD VSS CKND2
XU1263 n3572 n1286 VDD VSS INVD2
XU1264 n576 n1377 n575 VDD VSS IND2D1
XU1265 csa_sum_1[24] csa_carry_1[24] n1474 VDD VSS CKND2D8
XU1266 n2269 n236 VDD VSS INVD3
XU1267 n1105 n2307 VDD VSS CKND1
XU1271 n3484 FE_OCPN1178_n3485 n3486 VDD VSS ND2D3
XU1272 FE_OFN3431_n256 n3836 VDD VSS INVD0
XU1275 n1210 n1209 n3848 VDD VSS NR2XD2
XU1277 n2152 n240 n193 VDD VSS AN2D4
XU1278 n1337 n3253 n194 VDD VSS AN2D2
XU1279 n2392 n2397 n195 VDD VSS AN2D4
XU1280 n1813 n3687 n197 VDD VSS AN2D4
XU1282 n2316 n237 n200 VDD VSS XNR2D2
XU1284 n3005 n2998 n201 VDD VSS ND2D2
XU1285 n2853 n2788 VDD VSS CKND2
XU1286 n1410 n541 n202 VDD VSS AN2D4
XU1287 n2988 n2989 n203 VDD VSS AN2XD1
XU1289 n3603 n3224 VDD VSS BUFFD4
XU1290 n3603 n3724 VDD VSS BUFFD3
XU1293 x_mantissa[20] n2534 VDD VSS INVD2
XU1294 n2278 n2269 n205 VDD VSS AN2D4
XU1295 n3580 n3698 n206 VDD VSS CKAN2D0
XU1296 n3591 n973 n3592 n207 VDD VSS OA21D2
XU1297 n242 n3672 n208 VDD VSS AN2D4
XU1298 n285 n3223 n209 VDD VSS ND2D2
XU1299 n2255 n2254 FE_OFN3418_n3224 n210 VDD VSS OA21D4
XU1300 n210 n2099 n211 VDD VSS AN2D4
XU1301 n1673 n2451 n2457 VDD VSS ND2D4
XU1302 n1252 n1253 n2778 VDD VSS ND2D4
XU1303 n216 n1391 n215 VDD VSS AN2D4
XU1304 n1393 n1255 n216 VDD VSS AN2D4
XU1305 n1281 n1280 n217 VDD VSS AN2D4
XU1308 n307 n424 n2324 VDD VSS INR2XD2
XU1309 n740 n2754 n3581 VDD VSS ND2D4
XU1310 n81 n2775 n221 VDD VSS AN2D4
XU1311 n3526 n3527 n223 VDD VSS OR2D0
XU1312 n223 FE_OCPN1315_n3660 n224 VDD VSS AN2XD1
XU1313 n3684 n2736 n3685 VDD VSS ND2D2
XU1315 n3814 n3825 VDD VSS INVD1
XU1316 n3797 n3769 n3796 n3814 VDD VSS OAI21D1
XU1317 n1674 n508 n3769 n226 VDD VSS OR3D1
XU1318 n1775 n1166 n2236 VDD VSS NR2XD2
XU1319 n2236 n1145 VDD VSS CKND4
XU1320 n1649 n3334 n3333 n900 VDD VSS OAI21D1
XU1321 n900 n668 VDD VSS CKND2
XU1322 n2934 n1751 VDD VSS CKND4
XU1323 n2934 n2067 n1249 VDD VSS ND2D4
XU1324 n2889 n2241 VDD VSS CKND2
XU1325 FE_OCPN1319_n1815 n3377 n231 VDD VSS AN2D4
XU1327 FE_RN_128 n1414 n3343 n1413 VDD VSS ND3D4
XU1328 n554 n403 n563 VDD VSS ND2D8
XU1329 FE_RN_79 n2292 n1231 VDD VSS ND2D4
XU1331 n1662 n1928 n2351 VDD VSS ND2D4
XU1332 n3453 n3316 VDD VSS INVD2
XU1334 n1712 n1713 VDD VSS INVD0
XU1335 n656 n651 base_plane[24] VDD VSS ND2D2
XU1336 n1949 n788 n1948 VDD VSS ND2D4
XU1337 n2097 n211 n2096 VDD VSS ND2D4
XU1339 n1468 n513 n512 VDD VSS CKND2D2
XU1340 n3643 n3221 n1768 VDD VSS ND2D1
XU1341 n3250 n3246 n1046 VDD VSS CKND2D2
XU1342 n3653 n3652 n3654 VDD VSS AN2XD1
XU1343 n3380 n2268 VDD VSS INVD3
XU1344 n754 n3346 n753 VDD VSS ND2D1
XU1345 n3347 n585 n584 VDD VSS IND2D2
XU1346 n1866 n2538 n3613 VDD VSS CKND2D4
XU1347 n2623 n2622 n3244 VDD VSS ND2D1
XU1349 n246 n3116 n3380 VDD VSS ND2D4
XU1350 n2348 n3649 n3650 VDD VSS CKND2D1
XU1351 n1534 n1736 n3653 VDD VSS CKND2D4
XU1352 n2623 n1214 VDD VSS INVD1
XU1353 n3649 n3651 VDD VSS INVD1
XU1354 n3219 n2470 VDD VSS INVD2
XU1355 n2526 n1867 VDD VSS CKND2
XU1356 n1393 n3665 VDD VSS CKND2
XU1357 FE_OCPN1573_n3548 n3547 n3549 VDD VSS CKND2D2
XU1358 n2138 n232 VDD VSS INVD6
XU1359 n939 n3790 n3824 VDD VSS ND2D2
XU1360 n2217 n2213 n2526 VDD VSS CKND2D4
XU1361 n3231 n233 VDD VSS CKND4
XU1362 n1118 FE_OCPN1480_n2735 n2791 VDD VSS ND2D4
XU1363 n3057 n3063 n3121 VDD VSS ND2D2
XU1364 n1973 n1969 n3242 VDD VSS ND2D2
XU1365 n1272 FE_OFN3430_n2438 n1270 VDD VSS CKND2D1
XU1366 n3056 n1758 n3057 VDD VSS ND2D1
XU1367 n3331 n234 VDD VSS INVD2
XU1368 FE_OCPN1509_n1364 FE_OFN2725_n107 n2516 VDD VSS CKND2D8
XU1369 n1716 n2784 n1244 VDD VSS NR2D2
XU1370 n3709 n3562 n3710 VDD VSS XOR2D0
XU1371 n2045 n3176 n3175 n3178 VDD VSS OAI21D2
XU1372 n2792 n1115 VDD VSS INVD3
XU1373 n2602 FE_OFN3426_n2438 n2606 VDD VSS ND2D1
XU1374 n1395 n1389 n1242 VDD VSS INR2XD2
XU1375 n1373 n1744 n1372 VDD VSS CKND2D2
XU1376 n1146 n417 n1396 VDD VSS ND2D3
XU1377 n3024 n451 VDD VSS INVD0
XU1378 n1390 n1395 n1388 VDD VSS AN2D2
XU1380 n2729 n964 VDD VSS CKND4
XU1381 n2573 FE_OFN3430_n2438 n1197 VDD VSS CKND2D2
XU1382 n2106 n2248 n2877 VDD VSS ND2D4
XU1383 n1864 n3074 n3079 VDD VSS IND2D0
XU1384 n2798 n3258 n2259 VDD VSS CKAN2D0
XU1385 n1571 n602 VDD VSS CKND2
XU1386 n1224 n309 n2560 VDD VSS ND2D3
XU1387 n121 n196 n783 VDD VSS CKND2D3
XU1388 n2916 n2034 VDD VSS INVD1
XU1389 n3054 n2595 n2484 VDD VSS CKND2D2
XU1390 n3765 n1847 n505 VDD VSS AN2XD1
XU1391 n2796 n3014 n2313 VDD VSS AN2XD1
XU1392 n3794 n3768 n3769 VDD VSS OR2D1
XU1393 n2091 n1961 VDD VSS INVD0
XU1394 n3432 n3434 n3436 VDD VSS CKAN2D0
XU1395 FE_OCPN1296_n2751 n3103 n1800 VDD VSS ND2D2
XU1396 n3166 n325 n2142 VDD VSS NR2D0
XU1397 n2063 n1688 n2211 VDD VSS ND2D1
XU1398 n2228 n1971 n1087 VDD VSS AN2D0
XU1400 n2172 n2914 n2990 VDD VSS ND2D4
XU1401 n3411 FE_OFN103_n3196 n3198 VDD VSS AN2D1
XU1402 n1237 n2927 VDD VSS INVD0
XU1403 n1864 FE_OCPN3449_x_3 n332 VDD VSS ND2D2
XU1404 n904 n1237 n2923 VDD VSS ND2D1
XU1405 FE_OFN59_n180 n2599 n1269 VDD VSS INR2XD0
XU1406 n2910 n2920 n2911 VDD VSS CKND2D0
XU1407 n904 n2991 n2996 VDD VSS INR2D4
XU1408 n3144 n3019 VDD VSS INVD0
XU1409 n311 n3006 n3000 VDD VSS CKAN2D0
XU1411 n2995 n2921 VDD VSS INVD1
XU1412 n240 n1849 n2316 VDD VSS AN2XD1
XU1413 n3172 n3400 n3102 VDD VSS CKND2D3
XU1415 n2925 n2988 n2916 VDD VSS AN2D1
XU1416 n3810 n1728 VDD VSS INVD1
XU1417 n2919 n2920 n2995 VDD VSS CKND2D4
XU1418 FE_OFN103_n3196 n3410 n3416 VDD VSS INR2XD1
XU1419 n3012 n2393 VDD VSS INVD4
XU1421 n2878 n2136 VDD VSS INVD0
XU1422 FE_OFN2741_x_11 FE_OFN1376_n3256 n1395 VDD VSS OR2D0
XU1423 n327 n3154 n3015 VDD VSS CKND2D0
XU1424 x_mantissa[14] n69 n3004 VDD VSS INR2XD1
XU1425 n3165 n1704 n3173 VDD VSS CKND2D1
XU1426 n2824 n1636 n3403 VDD VSS ND2D1
XU1428 n3239 n2487 n3180 VDD VSS CKND2D1
XU1429 FE_OFN55_level_0 n2028 n3603 VDD VSS IND2D4
XU1431 n2277 n2276 mantissa_value[20] VDD VSS CKND2D8
XU1433 n654 n230 n651 VDD VSS NR2D2
XU1434 n718 n720 n717 VDD VSS ND2D2
XU1435 n1768 n1770 n1765 VDD VSS NR2XD0
XU1436 n265 n233 n2054 VDD VSS CKND2D2
XU1437 n806 n2163 base_plane[9] VDD VSS ND2D8
XU1438 n3823 n3830 n663 VDD VSS ND2D1
XU1439 n2179 n2268 n1838 VDD VSS NR2XD2
XU1441 n243 n3718 n739 VDD VSS IND2D1
XU1442 n3818 n2350 n3823 VDD VSS CKND2D1
XU1443 n2986 n269 VDD VSS CKND4
XU1444 n3702 n1997 n3703 VDD VSS AN2XD1
XU1445 n245 n3803 n3449 VDD VSS ND2D1
XU1446 n271 n2363 n3504 VDD VSS CKND2D1
XU1447 n3781 n3780 n1466 VDD VSS AN2XD1
XU1448 n3563 n274 n3721 VDD VSS ND2D1
XU1449 n3605 n3604 n3606 VDD VSS AN2D2
XU1450 n2625 n2624 n2626 VDD VSS NR2XD1
XU1451 n737 n274 n1997 VDD VSS CKND2D3
XU1452 n213 n3639 n3640 VDD VSS AN2XD1
XU1453 n2981 n275 VDD VSS CKND4
XU1454 n3805 n3784 n3799 VDD VSS OR2D1
XU1455 n2622 n1213 VDD VSS INVD1
XU1456 n3448 n3776 n3803 VDD VSS ND2D1
XU1457 n3665 n273 VDD VSS INVD2
XU1458 n3515 n3512 n3446 VDD VSS ND2D3
XU1459 n3476 n352 VDD VSS CKND2
XU1460 n3515 n3514 n3516 VDD VSS CKAN2D1
XU1462 n706 n1242 n2981 VDD VSS NR2XD3
XU1463 n233 n2140 n2138 VDD VSS CKND2D4
XU1464 n3667 n3668 n3669 VDD VSS AN2D2
XU1465 n287 FE_OCPN1513_n3475 n3476 VDD VSS AN2D4
XU1466 n1245 n1243 n706 VDD VSS ND2D4
XU1467 n3242 n1401 n3291 VDD VSS CKND2D2
XU1468 n2545 n1199 VDD VSS CKND2
XU1469 n3633 n3632 n3634 VDD VSS ND2D2
XU1470 n1954 n2479 n1263 VDD VSS CKND2D4
XU1471 n3121 n3123 VDD VSS INVD0
XU1472 n3107 n3108 n1955 n1954 VDD VSS OAI21D4
XU1473 n1244 n1243 VDD VSS CKND2
XU1474 FE_RN_78 n3668 VDD VSS CKND1
XU1476 n1396 n2524 VDD VSS INVD0
XU1477 n1012 n1314 VDD VSS CKND4
XU1478 n1293 n1292 n2829 VDD VSS CKND2D2
XU1479 n1396 FE_OFN3480_n46 n1437 n2874 VDD VSS AOI21D2
XU1480 n2045 FE_OFN102_n3172 n3173 n517 VDD VSS OAI21D2
XU1481 n1158 n1157 n1156 VDD VSS CKND2D3
XU1482 n2836 n2259 n1367 VDD VSS ND2D2
XU1483 n1734 n1401 VDD VSS CKND2
XU1484 n1364 n1282 VDD VSS INVD4
XU1485 n3797 n507 VDD VSS INVD1
XU1486 n1396 n3429 n2142 n2823 VDD VSS AOI21D4
XU1487 n845 n1176 n1845 VDD VSS ND2D4
XU1488 n2580 FE_OFN1367_n1643 n2585 VDD VSS ND2D1
XU1490 n1403 n1402 n1734 VDD VSS ND2D2
XU1491 n1627 n3258 n1970 VDD VSS CKND2D2
XU1492 n3278 n1375 n3304 VDD VSS INR2XD1
XU1493 FE_RN_111 n1925 VDD VSS INVD6
XU1494 n1912 n235 VDD VSS INVD6
XU1495 n477 n3026 n460 VDD VSS ND2D2
XU1496 n3526 n3527 n3660 VDD VSS ND2D4
XU1497 n3705 n3704 n1486 VDD VSS ND2D1
XU1498 n1117 n1116 n2792 VDD VSS ND2D2
XU1499 n3051 n3090 VDD VSS INVD1
XU1500 FE_OCPN3463_n87 n289 n1953 VDD VSS CKND2D1
XU1501 n3233 n3429 n1403 VDD VSS ND2D1
XU1502 n1671 n1670 n598 VDD VSS ND2D4
XU1503 n3236 n3438 n1972 VDD VSS CKAN2D0
XU1504 n3240 FE_OFN3429_n2438 n1822 VDD VSS CKND2D1
XU1505 n3109 n2479 VDD VSS CKND6
XU1507 n2931 n2819 n3236 VDD VSS CKND2D2
XU1508 n3054 n3053 n1725 n3055 VDD VSS ND3D1
XU1509 n3159 n1472 VDD VSS INVD1
XU1510 FE_RN_42 n1706 n333 VDD VSS CKND2D4
XU1511 n185 n2867 VDD VSS INVD1
XU1513 n2835 n1346 VDD VSS INVD0
XU1514 n3530 n2556 n3839 VDD VSS XNR2D1
XU1515 n2220 n2608 n1809 VDD VSS ND2D1
XU1516 n256 n2878 n1991 VDD VSS ND2D1
XU1517 n2063 n52 n1841 VDD VSS ND2D2
XU1518 n3434 n3761 n3409 VDD VSS CKAN2D1
XU1519 n3832 n3834 VDD VSS BUFFD1
XU1520 n3425 n3770 n3417 VDD VSS CKAN2D1
XU1521 n2503 n2502 n2506 VDD VSS CKND2D1
XU1522 FE_OCPN3460_n2753 FE_OFN2743_y_20 n1812 VDD VSS INR2D1
XU1524 n2996 n2993 n3153 VDD VSS CKND2D2
XU1525 n3082 n300 VDD VSS INVD1
XU1526 n2147 n1632 n2399 VDD VSS CKND2D2
XU1527 n2911 n1656 VDD VSS INVD0
XU1528 n3167 n3174 n3168 VDD VSS AN2D1
XU1529 n53 FE_OCPN3449_x_3 n1915 VDD VSS ND2D1
XU1530 n2803 n2871 n604 VDD VSS AN2XD1
XU1531 n1675 n3180 n3163 VDD VSS CKAN2D1
XU1532 n2998 n311 n3018 VDD VSS CKND2D2
XU1533 n3748 n305 VDD VSS INVD2
XU1534 n3162 n1687 n2246 VDD VSS NR2XD0
XU1535 n2166 n1387 VDD VSS INVD0
XU1536 n2595 n3114 n2061 VDD VSS CKAN2D0
XU1537 FE_OFN2752_x_21 FE_OFN104_n3401 n3276 VDD VSS ND2D1
XU1538 n2841 n3138 n1524 VDD VSS ND2D1
XU1541 n2000 n68 n2407 VDD VSS XOR2D0
XU1542 n2430 n3199 n2474 VDD VSS XOR2D0
XU1544 FE_OCPN1464_n2628 n987 n3269 VDD VSS ND2D1
XU1545 n3188 n3403 n3177 VDD VSS AN2D1
XU1546 n318 FE_OFN2753_x_18 n1292 VDD VSS CKND2D0
XU1547 n2397 n2202 n3033 VDD VSS ND2D2
XU1549 n2395 n1398 n3150 VDD VSS CKXOR2D2
XU1550 n2715 n3036 VDD VSS BUFFD4
XU1554 FE_OCPN1544_n2261 FE_OCPN1424_n1137 n3353 VDD VSS AN2D4
XU1556 n3497 FE_OCPN1214_n972 n3499 VDD VSS CKND2D1
XU1557 n1765 n1762 n1761 VDD VSS NR2XD1
XU1558 n249 n3750 n410 n577 VDD VSS ND3D2
XU1559 n3247 n2328 n1884 VDD VSS NR2XD0
XU1560 n3822 n3830 n661 VDD VSS IND2D1
XU1561 n269 n273 n2204 VDD VSS CKND2D2
XU1562 n1278 n284 n2358 VDD VSS CKND2D2
XU1563 n486 n3802 n485 VDD VSS ND2D0
XU1564 n1835 n2179 n1834 VDD VSS CKND2D1
XU1565 n3246 n268 n3245 n3247 VDD VSS AO21D1
XU1566 n3775 n1568 n3782 VDD VSS ND2D1
XU1567 n3826 n3829 n3830 VDD VSS ND2D1
XU1568 n3720 n243 VDD VSS INVD1
XU1569 n2350 n3819 n3809 VDD VSS AN2XD1
XU1570 n3825 n3816 n3817 VDD VSS CKND2D1
XU1571 n3808 n3807 n3819 VDD VSS CKND2D1
XU1572 n209 FE_OCPN3458_n3475 n1803 VDD VSS AN2XD1
XU1573 n1344 n1343 VDD VSS INVD2
XU1574 n3470 n3560 VDD VSS INVD1
XU1575 n275 FE_RN_101 n2986 VDD VSS CKND2D4
XU1576 n2254 n2255 n2207 VDD VSS CKND2D1
XU1577 n3133 n1933 n3720 VDD VSS IND2D1
XU1578 n3210 n1587 VDD VSS INVD0
XU1579 n2625 n2624 n3249 VDD VSS ND2D1
XU1580 n3506 n3505 n3507 VDD VSS ND2D1
XU1581 n705 n704 n1621 VDD VSS CKND2D1
XU1582 n249 n3751 n523 VDD VSS AN2XD1
XU1583 n2621 n1894 VDD VSS INVD1
XU1584 n950 n1734 n2341 VDD VSS ND2D3
XU1586 n248 FE_OCPN1493_n3670 n3671 VDD VSS ND2D1
XU1588 n2349 n3543 n469 VDD VSS AN2XD1
XU1589 n281 n3208 n3419 VDD VSS ND2D1
XU1590 n3806 n3784 VDD VSS INVD0
XU1591 n3242 n950 VDD VSS CKND2
XU1592 n250 n470 n3541 VDD VSS ND2D3
XU1593 n3205 n3204 n3754 VDD VSS ND2D2
XU1594 n706 n1388 n2980 VDD VSS ND2D4
XU1595 n1857 n249 VDD VSS INVD4
XU1596 n1975 n1978 n2530 VDD VSS CKND2D4
XU1597 FE_OCPN1590_n2366 FE_OCPN1605_n3345 n3346 VDD VSS ND2D2
XU1598 n285 n287 n2876 VDD VSS CKND2D4
XU1599 n415 n414 n3466 VDD VSS CKND2D2
XU1600 n1247 n1246 n2469 VDD VSS CKND2D4
XU1601 n1483 n1482 n3132 VDD VSS ND2D1
XU1602 n1568 n284 VDD VSS CKND2
XU1603 n1989 n1988 n2882 VDD VSS ND2D4
XU1604 n3091 n30 n1931 VDD VSS ND2D1
XU1605 n3436 n940 n938 VDD VSS CKND2D1
XU1607 n2585 n2584 n2586 VDD VSS CKND2D2
XU1608 n1972 n1627 n1970 n1969 VDD VSS OAI21D1
XU1609 n1654 n2836 n1346 n1345 VDD VSS ND3D2
XU1610 n2398 n2446 n2249 VDD VSS CKND2D1
XU1611 n1845 n1858 n1844 VDD VSS CKND2D4
XU1612 n1120 n1232 n1119 VDD VSS CKND2D2
XU1613 n3562 n3561 n1484 VDD VSS CKND2D1
XU1614 n1925 n1387 n679 VDD VSS CKND2D3
XU1615 n2807 n2225 VDD VSS INVD2
XU1616 n3122 n736 n3063 n3060 VDD VSS OAI21D1
XU1619 n3705 n3072 n3078 VDD VSS CKND2D1
XU1621 n254 n629 n2239 n2856 VDD VSS IOA21D2
XU1622 FE_PSN1638_n2844 FE_OFN2745_y_20 n1009 n2468 VDD VSS OAI21D4
XU1623 n1274 n3267 n1518 VDD VSS AN2XD1
XU1625 n1327 n93 n2239 VDD VSS CKND2D2
XU1626 n1327 n296 n1326 VDD VSS CKND2D4
XU1627 n1984 n2124 n645 VDD VSS ND2D1
XU1628 n290 n2998 n2999 VDD VSS CKND2D2
XU1629 n3236 n289 VDD VSS INVD1
XU1630 n3069 n1361 n251 n1280 VDD VSS IAO21D1
XU1631 n503 n502 n501 VDD VSS CKND2D1
XU1632 n82 n2395 n2061 n2505 VDD VSS OAI21D4
XU1633 n1091 n2228 n1654 VDD VSS ND2D2
XU1634 n1984 n2775 n3262 VDD VSS AN2D2
XU1635 n2010 n1433 VDD VSS CKND1
XU1636 n1706 n300 n3081 n2011 n2010 VDD VSS AOI31D1
XU1638 n2288 n2921 n2287 n2923 n2286 VDD VSS AO22D2
XU1639 n1385 FE_OFN2795_n1743 n1384 VDD VSS CKND2D0
XU1640 n3765 n503 VDD VSS INVD0
XU1642 n2714 n2790 n1917 VDD VSS CKND2D2
XU1643 n2752 n2596 n1052 VDD VSS ND2D2
XU1644 n3423 n3425 n3427 VDD VSS CKND2D1
XU1645 n3081 n120 n1727 VDD VSS CKND2D8
XU1646 FE_OFN2795_n1743 FE_OFN2810_n2892 n690 VDD VSS CKND2D1
XU1647 n1574 FE_OFN2739_x_10 n1188 VDD VSS CKND2D0
XU1648 n894 n893 n895 VDD VSS ND2D4
XU1649 n2091 n2909 n1962 VDD VSS OR2D1
XU1650 n2722 n258 n1447 VDD VSS AN2D4
XU1651 n2571 FE_OCPN3456_FE_RN_41 n1891 VDD VSS CKND2D1
XU1652 n300 n323 n1434 VDD VSS CKND2D1
XU1653 n301 DP_OP_49_177_9047_n57 n986 VDD VSS CKND2D0
XU1654 n3260 n1374 VDD VSS INVD0
XU1655 n3303 n3307 VDD VSS INVD1
XU1657 n3150 n786 VDD VSS INVD0
XU1659 n3792 n56 n3793 VDD VSS NR2XD0
XU1660 n2922 n2921 n2287 VDD VSS CKND2D1
XU1661 n2583 n2582 n2584 VDD VSS CKND2D0
XU1664 n3162 n2477 VDD VSS CKND2
XU1666 n3299 n1711 n688 VDD VSS ND2D2
XU1668 n3771 n3770 n3792 VDD VSS CKND2D1
XU1669 n2553 FE_OCPN1495_n1916 n1222 VDD VSS ND2D2
XU1670 n2407 n1475 VDD VSS INVD0
XU1671 n2512 n1738 VDD VSS INVD0
XU1672 n257 n1123 n1121 VDD VSS CKND2D2
XU1673 n2583 FE_OFN98_n300 n2424 VDD VSS ND2D1
XU1674 n3767 n3430 VDD VSS INVD1
XU1675 n2825 n2779 n1178 VDD VSS AN2XD1
XU1676 n319 n1515 n3014 VDD VSS ND2D1
XU1677 n508 n259 n1432 VDD VSS NR2XD0
XU1678 n3009 n3141 n3010 VDD VSS CKAN2D1
XU1679 n3407 n3402 n3760 VDD VSS ND2D1
XU1680 n3192 n3404 n3193 VDD VSS CKND2D0
XU1681 FE_OCPN1464_n2628 FE_OFN3409_y_17 n835 VDD VSS AN2XD1
XU1682 n318 n2504 n1402 VDD VSS CKND2D0
XU1685 n2186 n2460 n1005 VDD VSS AN2D4
XU1686 n3404 n3403 n3405 VDD VSS CKND2D1
XU1687 n2919 n2151 VDD VSS BUFFD0
XU1688 n3174 n3173 n3406 VDD VSS ND2D1
XU1689 n1577 add_x_7_B_19_ n3770 VDD VSS ND2D1
XU1690 n3181 n3180 n3415 VDD VSS ND2D2
XU1691 n3413 n3412 n3414 VDD VSS CKND2D1
XU1692 FE_OCPN3517_n3128 n239 VDD VSS INVD2
XU1696 n1578 n1711 n3013 VDD VSS ND2D1
XU1697 n3155 n3154 n3156 VDD VSS CKND2D1
XU1698 n1398 n2824 n3174 VDD VSS CKND2D1
XU1709 divided_plane[28] n1758 n3838 VDD VSS ND2D2
XU1710 divided_plane[20] n305 n2277 VDD VSS ND2D8
XU1711 n1680 n89 n1426 mantissa_value[16] VDD VSS IOA21D4
XU1712 divided_plane[16] n3837 n1426 VDD VSS CKND2D2
XU1713 shared_plane[2] divided_plane[2] n3836 mantissa_value[2] VDD VSS MUX2D2
XU1714 FE_OCPN1292_n3360 n3359 n1680 VDD VSS XOR2D0
XU1715 csa_sum_1[24] csa_carry_1[24] n3314 VDD VSS NR2XD2
XU1716 n2954 n2955 n2956 VDD VSS ND2D2
XU1717 n659 n658 n657 n656 VDD VSS ND3D2
XU1718 n660 n1875 n657 VDD VSS CKND2D1
XU1720 n1308 n1598 n892 VDD VSS CKND2D2
XU1721 n1769 n1767 n1766 VDD VSS NR2D2
XU1723 n661 n662 n658 VDD VSS CKND2D1
XU1724 n3247 n2328 n3321 n1887 VDD VSS AOI21D1
XU1725 n663 n3822 n662 VDD VSS CKND2D1
XU1726 FE_RN_65 n3220 n891 VDD VSS CKND2D2
XU1727 n267 n233 n283 n2263 VDD VSS AOI21D2
XU1728 n1171 FE_OCPN1565_n3384 n1998 VDD VSS ND2D8
XU1729 n1342 n692 n691 VDD VSS NR2XD1
XU1731 n2358 n3782 n515 VDD VSS AN2XD1
XU1732 n1343 n2985 n1342 VDD VSS NR2XD1
XU1733 n3617 n770 n769 VDD VSS NR2XD2
XU1734 n3822 n3830 n660 VDD VSS AN2XD1
XU1736 csa_sum_1[1] csa_carry_1[1] n3384 VDD VSS CKND2D8
XU1737 n3593 n3592 n3594 VDD VSS CKND2D1
XU1738 n3656 n3246 n3248 VDD VSS AN2XD1
XU1739 n752 n749 n748 VDD VSS NR2D1
XU1740 n3830 n665 VDD VSS INVD0
XU1741 FE_OCPN1559_n2009 n1987 n1986 VDD VSS ND2D2
XU1742 n1343 FE_RN_5 n695 VDD VSS NR2D2
XU1743 n269 n1343 n1033 VDD VSS ND2D1
XU1744 n2821 n442 n3616 VDD VSS ND2D4
XU1746 n3570 n3574 n1798 VDD VSS NR2XD3
XU1747 n3449 n3447 n1180 VDD VSS CKND2D1
XU1748 n3817 n89 n655 VDD VSS ND2D1
XU1749 n2219 n3647 n3648 VDD VSS ND2D1
XU1750 n3244 n2626 n3249 n1097 VDD VSS OAI21D1
XU1752 n2876 n2254 n2098 VDD VSS NR2XD1
XU1753 FE_OCPN1612_n1255 n2982 n2983 VDD VSS AN2D2
XU1754 n3813 n3800 VDD VSS INVD1
XU1755 n3221 n1764 VDD VSS INVD1
XU1756 n2005 n2357 n3559 VDD VSS NR2D1
XU1757 n499 n498 n3775 VDD VSS ND2D1
XU1758 csa_carry_1[1] n1999 VDD VSS INVD0
XU1760 n751 n3344 n750 VDD VSS INR2XD1
XU1761 n2544 n1771 VDD VSS INVD1
XU1762 n2413 n3646 n1508 VDD VSS IND2D4
XU1763 n2341 n3291 n3243 VDD VSS CKND2D2
XU1764 n1568 n1467 n3780 VDD VSS CKND2D1
XU1765 n1480 n1482 n3460 VDD VSS CKND2D0
XU1766 n2226 n1733 VDD VSS CKND4
XU1767 n232 n2341 n770 VDD VSS ND2D4
XU1768 n3598 n244 VDD VSS INVD4
XU1769 n3596 n3595 n3597 VDD VSS AN2XD1
XU1770 n1521 n1522 n899 VDD VSS ND2D2
XU1771 n3713 n3712 n3714 VDD VSS CKND2D1
XU1772 n2542 n2150 n1772 n2544 VDD VSS OAI21D2
XU1773 n3115 n1264 VDD VSS INVD2
XU1774 n3664 n1428 VDD VSS INVD1
XU1775 n1565 n2612 n2634 n2623 n2624 VDD VSS FA1D1
XU1776 n3801 n245 VDD VSS INVD1
XU1777 n1564 n1702 n3556 n3312 n3558 VDD VSS FA1D0
XU1778 n2363 n3419 n3202 VDD VSS AN2D0
XU1779 n3374 n3373 n3375 VDD VSS CKND2D1
XU1780 n2531 n2532 n3227 VDD VSS ND2D1
XU1781 n3322 n1723 n3323 VDD VSS CKND2D1
XU1782 n3825 n3824 n3826 VDD VSS XNR2D0
XU1783 n1084 n1083 VDD VSS INVD4
XU1784 n2876 n246 VDD VSS CKND4
XU1785 FE_OCPN1588_n3540 n3344 VDD VSS INVD1
XU1786 n233 n3618 n2330 VDD VSS CKAN2D1
XU1787 n3754 n247 VDD VSS INVD3
XU1788 n3333 n1530 VDD VSS CKND2
XU1789 n931 FE_OFN3420_n2829 n3232 VDD VSS ND2D4
XU1790 n1019 n3545 VDD VSS INVD4
XU1791 n2791 FE_OCPN1187_n1844 n1340 VDD VSS ND2D1
XU1792 n3444 n1781 VDD VSS INVD1
XU1793 FE_OFN3405_n3209 n3208 n3443 VDD VSS ND2D1
XU1794 n2221 n2855 n3687 VDD VSS ND2D4
XU1795 n2169 n2165 n1394 n1393 VDD VSS ND3D8
XU1796 n939 n505 n504 VDD VSS ND2D1
XU1799 n3711 n1484 n1483 VDD VSS ND2D1
XU1800 n940 n786 n592 VDD VSS XOR2D4
XU1801 n2823 n2822 n3618 VDD VSS ND2D3
XU1802 n2586 FE_OFN3427_n2438 n2587 VDD VSS XNR2D0
XU1803 n416 n2789 n415 VDD VSS CKND2D1
XU1804 n3284 n262 n1002 VDD VSS AN2D1
XU1805 n2578 n2520 FE_OFN109_n251 n2160 VDD VSS ND3D2
XU1807 n1196 n304 n1195 n2616 VDD VSS OAI21D4
XU1808 n3760 n2045 n3789 n2025 VDD VSS OAI21D2
XU1809 n2611 FE_OFN2744_y_20 n2610 n2632 VDD VSS OAI21D4
XU1810 n2543 n2150 n1772 VDD VSS CKND2D1
XU1811 n2805 n2775 n2227 VDD VSS AN2XD1
XU1812 n3257 n1375 n1745 VDD VSS ND2D1
XU1813 n3522 n3523 n3524 VDD VSS ND2D1
XU1814 n2448 n423 VDD VSS INVD4
XU1815 n2631 n2629 n2630 VDD VSS CKXOR2D1
XU1816 n2864 n1079 VDD VSS INVD1
XU1817 n1448 n1447 n1446 VDD VSS CKND2D2
XU1818 n451 n450 n462 VDD VSS ND2D1
XU1819 n1443 n1445 n1442 VDD VSS ND2D2
XU1820 n2215 n2214 VDD VSS INVD1
XU1821 n2577 FE_OFN2745_y_20 n1892 VDD VSS IND2D1
XU1822 n1737 n3429 n1293 VDD VSS ND2D2
XU1823 n3160 n3198 n3197 n648 VDD VSS AOI21D1
XU1824 n2788 n2168 n2167 VDD VSS CKND2D1
XU1825 n1376 n1374 n1373 VDD VSS ND2D2
XU1826 n295 n2797 n2154 VDD VSS AN2XD1
XU1828 n2803 n2868 n3050 n2807 VDD VSS MUX2ND2
XU1829 n1189 n1188 n2466 VDD VSS ND2D2
XU1830 n2576 n2577 VDD VSS INVD1
XU1831 n2428 n703 n1191 VDD VSS CKND2D1
XU1833 n511 n510 n3774 n508 n509 VDD VSS OAI22D1
XU1834 n1506 FE_OFN3425_n2438 n1246 VDD VSS ND2D1
XU1835 n2931 FE_OCPN1536_n3240 n2184 VDD VSS INR2XD1
XU1836 n2774 n325 n1390 VDD VSS ND2D2
XU1837 n3112 n2504 n72 n3233 VDD VSS MUX2ND0
XU1838 n3098 n2867 n1979 VDD VSS INR2XD0
XU1839 n2854 n325 n1117 VDD VSS CKND2D1
XU1840 n1632 n188 n783 n2832 VDD VSS OAI21D4
XU1841 n3003 n2313 n1412 VDD VSS AN2XD1
XU1842 n2267 n2266 n2303 VDD VSS IND2D0
XU1843 n3074 n3075 VDD VSS INVD1
XU1844 FE_OFN3485_n3071 n3074 n3072 VDD VSS NR2D1
XU1845 n1316 n2563 VDD VSS INVD1
XU1846 n916 n2211 n1697 VDD VSS ND2D4
XU1847 n3055 n2051 VDD VSS INVD1
XU1848 n2854 n296 n1189 VDD VSS CKND2D1
XU1849 n690 n3258 n689 VDD VSS AN2XD1
XU1850 n687 n688 n2083 VDD VSS ND2D4
XU1851 n1178 FE_RN_145 n1177 VDD VSS NR2D4
XU1852 n2804 n91 n916 VDD VSS ND2D4
XU1853 n3408 n2819 n924 VDD VSS OR2D1
XU1855 n797 n316 n796 VDD VSS ND2D4
XU1856 n3153 n291 n1186 VDD VSS NR2XD0
XU1857 n3774 n56 n511 VDD VSS CKND2D1
XU1859 n3788 n3760 n1846 VDD VSS NR2D1
XU1860 n3833 n253 VDD VSS INVD0
XU1861 n2779 FE_OFN2805_y_13 n1385 VDD VSS NR2XD0
XU1863 n328 n1232 n1010 VDD VSS INR2D1
XU1864 n176 n3067 n3706 VDD VSS IND2D1
XU1865 FE_OFN2790_n3795 n3794 n3793 n3796 VDD VSS OA21D0
XU1866 n2921 n2923 n2289 VDD VSS CKND2D1
XU1867 n2923 n2288 VDD VSS INVD1
XU1868 n3763 n3788 VDD VSS INVD1
XU1869 n1574 n2600 n2124 VDD VSS AN2XD1
XU1870 n2477 n1635 n2878 n2478 VDD VSS ND3D1
XU1871 n301 n95 n1080 VDD VSS NR2XD0
XU1872 n1808 FE_OCPN1583_n92 n1077 VDD VSS CKND2D1
XU1873 n2424 n298 n777 VDD VSS CKND2D1
XU1874 n794 n793 VDD VSS INVD0
XU1875 n3430 n3771 n3431 VDD VSS AN2D1
XU1879 n3169 n3181 n3170 VDD VSS CKAN2D1
XU1880 n3770 n3424 VDD VSS INVD1
XU1881 n1675 n2201 VDD VSS INVD0
XU1882 n2594 n2600 VDD VSS INVD1
XU1883 n1725 n3299 n3270 VDD VSS ND2D1
XU1885 n2393 n3013 n2326 VDD VSS ND2D1
XU1886 n2540 n2776 n1072 n2431 VDD VSS AN3D4
XU1887 n3406 n3175 VDD VSS INVD1
XU1889 n3762 n3761 n3786 VDD VSS CKND2D1
XU1892 FE_OFN2810_n2892 n1947 FE_OFN1359_n323 n2815 VDD VSS AOI21D1
XU1894 FE_OFN2752_x_21 FE_OFN104_n3401 n3260 VDD VSS IND2D0
XU1895 n65 n3428 n794 VDD VSS INR2XD0
XU1896 n822 n3756 VDD VSS INVD1
XU1897 FE_OFN2752_x_21 n1725 n3259 VDD VSS CKND2D1
XU1899 n2902 n2919 n2903 VDD VSS AN2XD1
XU1900 n68 n94 n597 VDD VSS INR2XD0
XU1902 FE_OFN2789_x_4 n3428 n817 VDD VSS INR2XD0
XU1904 n2838 n95 n384 VDD VSS INR2XD0
XU1905 FE_OFN103_n3196 n3412 n3184 VDD VSS CKND2D1
XU1906 n2485 FE_OFN3409_y_17 n3162 VDD VSS ND2D2
XU1907 n2806 n2994 n2323 VDD VSS ND2D1
XU1909 n327 n3239 n1361 VDD VSS CKND2D0
XU1911 n3142 n3141 n3143 VDD VSS CKND2D1
XU1912 n2583 n465 n2429 VDD VSS ND2D1
XU1913 x_mantissa[20] n176 n1235 VDD VSS IND2D1
XU1915 n3106 n1572 VDD VSS BUFFD2
XU1916 n1003 n3129 n2589 VDD VSS OR2D1
XU1917 n322 n3282 n3762 VDD VSS CKND2D1
XU1919 n322 n3282 n3758 VDD VSS NR2XD0
XU1920 n2499 n241 n3761 VDD VSS ND2D1
XU1921 n1271 n241 n3759 VDD VSS NR2XD0
XU1922 n2581 n1577 n3767 VDD VSS NR2D1
XU1925 n2581 n1577 n3771 VDD VSS CKND2D1
XU1928 n1271 n3191 n3404 VDD VSS CKND2D1
XU1930 n1100 FE_OFN1376_n3256 n1116 VDD VSS OR2D1
XU1931 n2715 n2594 VDD VSS BUFFD4
XU1935 n3165 n1704 n3172 VDD VSS NR2XD1
XU1941 n1636 FE_OFN73_n2417 n634 VDD VSS IND2D1
XU1948 FE_OCPN3455_shared_plane_12 divided_plane[12] FE_OFN3488_n3837
+ mantissa_value[12] VDD VSS MUX2D4
XU1949 divided_plane[6] n3833 n1514 VDD VSS CKND2D1
XU1950 divided_plane[5] n3833 n1907 VDD VSS CKND2D1
XU1951 n1683 divided_plane[1] n1569 mantissa_value[1] VDD VSS MUX2D2
XU1952 n2953 n578 VDD VSS INVD2
XU1953 n2975 n1310 VDD VSS CKND2
XU1955 n2644 n3314 n2969 VDD VSS NR2D4
XU1957 csa_sum_1[21] csa_carry_1[21] n2381 VDD VSS NR2D4
XU1958 csa_sum_1[28] csa_carry_1[28] n2955 VDD VSS ND2D1
XU1959 csa_sum_1[28] csa_carry_1[28] n2954 VDD VSS OR2XD1
XU1960 n3566 n3719 n3841 VDD VSS AN2D4
XU1961 n3725 n3724 n2311 VDD VSS CKAN2D1
XU1962 n1665 n3717 n834 VDD VSS ND2D2
XU1963 n2041 n2042 base_plane[19] VDD VSS ND2D4
XU1964 n3450 FE_OFN1367_n1643 n3451 VDD VSS ND2D2
XU1965 n1588 n1589 n3211 VDD VSS ND2D3
XU1966 n492 n491 n494 VDD VSS ND2D1
XU1967 n776 n775 n3858 VDD VSS NR2D4
XU1968 n1558 n1559 n2262 VDD VSS ND2D2
XU1969 n1889 n3248 n1888 VDD VSS ND2D2
XU1970 n1778 n245 n997 n487 VDD VSS AOI21D4
XU1971 n721 n719 VDD VSS CKND2
XU1972 FE_RN_147 n1875 VDD VSS INVD1
XU1973 n1834 n1832 n1831 VDD VSS ND2D2
XU1976 n452 n581 n580 n1589 VDD VSS ND3D2
XU1977 n1439 FE_OCPN1196_n883 n2968 VDD VSS ND2D2
XU1978 n438 n90 n2943 VDD VSS CKND2D4
XU1981 n3366 FE_OCPN1503_n3384 shared_plane[2] VDD VSS XOR2D4
XU1982 n718 n720 n3638 n715 VDD VSS OAI21D1
XU1983 n1045 n1097 n720 VDD VSS NR2D4
XU1984 n1763 n1762 VDD VSS INVD2
XU1985 n849 n848 VDD VSS INVD2
XU1986 n3812 n3813 n653 n652 VDD VSS AN3XD1
XU1987 n1025 n1024 n3497 VDD VSS CKND2D4
XU1988 n723 n748 n1787 VDD VSS CKND2D3
XU1990 n3572 n1289 n310 n1287 VDD VSS AOI21D2
XU1991 n2643 n2959 n2297 VDD VSS AN2XD1
XU1992 n2358 n3780 n1747 VDD VSS AN2XD1
XU1993 n1829 n244 n849 VDD VSS ND2D2
XU1994 n1548 n3504 n1547 VDD VSS NR2D2
XU1995 FE_OFN2792_n546 n695 n694 VDD VSS ND2D3
XU1996 n3823 n665 n664 VDD VSS IND2D1
XU1997 n440 n2036 n439 VDD VSS ND2D4
XU1998 FE_RN_113 n264 VDD VSS INVD4
XU1999 n3821 n1457 VDD VSS INVD1
XU2000 n3212 n2960 n2959 n2961 VDD VSS OAI21D1
XU2001 n1986 n207 n1318 VDD VSS ND2D4
XU2002 n3643 n3221 n3251 n1769 VDD VSS OAI21D1
XU2003 n1231 n3687 FE_OCPN1584_n1813 n712 VDD VSS AOI21D4
XU2004 n2204 n1817 VDD VSS INVD2
XU2005 n1172 n1999 n1171 VDD VSS CKND2D4
XU2006 n2960 n2643 VDD VSS INVD0
XU2007 n3513 n1261 VDD VSS INVD1
XU2008 n3250 n3249 n2328 VDD VSS CKAN2D1
XU2009 n3804 n486 VDD VSS INVD1
XU2010 n243 n3718 n1489 VDD VSS ND2D1
XU2011 n1777 n1330 VDD VSS CKND2
XU2012 n3471 n2005 VDD VSS INVD1
XU2013 n2821 n2820 n2312 VDD VSS CKND2D1
XU2014 n3775 n1278 VDD VSS INVD1
XU2015 n3656 n3655 n3657 VDD VSS AN2XD1
XU2016 n1951 n3699 n1950 VDD VSS NR2XD1
XU2017 n3804 n3803 n3802 n3821 VDD VSS OAI21D2
XU2018 n3617 n265 VDD VSS CKND4
XU2019 n2957 n266 VDD VSS CKND2
XU2020 n2545 n2544 n1379 VDD VSS ND2D2
XU2021 n3244 n3245 VDD VSS INVD1
XU2022 n750 n3346 n749 VDD VSS AN2XD1
XU2023 n3510 n3210 n581 VDD VSS AN2XD1
XU2025 n3696 n1951 VDD VSS INVD1
XU2027 n3379 n3381 n3382 n1451 VDD VSS OA21D4
XU2028 n444 n3291 n443 VDD VSS CKND2D4
XU2029 n3135 n3134 n3136 VDD VSS NR2D1
XU2030 n3715 n3714 n3716 VDD VSS ND2D1
XU2031 n3470 n3471 n2329 VDD VSS CKAN2D1
XU2032 n3808 n3807 n2350 VDD VSS OR2D1
XU2033 n3461 n3460 n3462 VDD VSS OR2XD1
XU2034 n3817 FE_OFN3423_n1728 n653 VDD VSS NR2XD0
XU2035 FE_OCPN1556_n3554 n1161 VDD VSS INVD1
XU2036 n2820 n3670 n442 VDD VSS ND2D2
XU2037 n3349 n791 VDD VSS INVD1
XU2038 n3312 n3311 n3313 VDD VSS OR2XD1
XU2039 n3218 n1332 VDD VSS INVD1
XU2040 n2140 n3232 n2830 VDD VSS CKAN2D1
XU2041 n3324 n3323 n3325 VDD VSS ND2D1
XU2042 n2027 n530 VDD VSS CKND2
XU2043 FE_RN_46 n534 n1063 n531 VDD VSS ND3D2
XU2044 n3612 n1107 VDD VSS INVD4
XU2046 n899 n897 VDD VSS INVD1
XU2047 n3589 n3588 n3590 VDD VSS AN2XD1
XU2048 n1981 n3296 n3673 VDD VSS INR2XD2
XU2049 n3297 n3298 n3591 VDD VSS NR2XD2
XU2050 n3298 n3297 n3592 VDD VSS ND2D1
XU2051 n3753 n3372 VDD VSS INVD1
XU2052 n3395 FE_OCPN1608_n3394 n3396 VDD VSS AN2XD1
XU2053 n3587 n3585 n3696 VDD VSS NR2D2
XU2054 n3133 n3132 n3718 VDD VSS ND2D1
XU2055 n1565 n2632 n2634 n2625 n2638 VDD VSS FA1D1
XU2056 n3806 n3805 n3777 n3808 VDD VSS HA1D1
XU2057 n1481 n1482 n3134 VDD VSS CKND2D0
XU2058 n2133 n1079 n386 VDD VSS CKND2D3
XU2059 n1993 n2541 n2543 n2542 VDD VSS AO21D1
XU2060 n3622 n3219 n1073 VDD VSS ND2D2
XU2061 n506 n226 n3805 n498 VDD VSS ND3D1
XU2062 n3448 n3776 n3801 VDD VSS NR2D1
XU2063 n3549 n814 VDD VSS INVD1
XU2064 n3132 n1933 VDD VSS INVD1
XU2066 n3512 n3443 n3210 VDD VSS CKAN2D1
XU2067 n3309 n3308 n3471 VDD VSS ND2D1
XU2068 FE_OCPN1568_n2349 n585 VDD VSS INVD1
XU2069 n3390 n3641 n2308 VDD VSS AN2D4
XU2070 n506 n226 n3805 n499 VDD VSS AO21D1
XU2071 n1207 n2412 n2413 VDD VSS NR2XD3
XU2072 n3469 n3468 n3674 VDD VSS NR2XD1
XU2073 n2159 n2158 n2532 VDD VSS CKND2D3
XU2074 n3469 n3468 n3675 VDD VSS ND2D1
XU2075 n2365 n3348 n3349 VDD VSS CKAN2D2
XU2076 n3511 n3515 n642 VDD VSS ND2D2
XU2077 n1722 n838 VDD VSS INVD1
XU2078 n1882 n1881 VDD VSS CKND4
XU2079 n1565 n2614 n2613 n2621 n2622 VDD VSS FA1D1
XU2080 n3541 FE_OCPN1588_n3540 n3542 VDD VSS AN2XD1
XU2081 n2771 FE_OFN3423_n1728 n2772 VDD VSS ND2D4
XU2082 n1530 n1522 n3185 n1529 VDD VSS AOI21D4
XU2083 n3541 n751 VDD VSS CKND2
XU2084 n3346 n747 VDD VSS INVD2
XU2085 n1722 n1485 n3461 VDD VSS XOR2D0
XU2086 n2483 n2160 n2159 VDD VSS ND2D2
XU2087 n930 n3295 n3393 VDD VSS NR2D8
XU2088 n3185 n1521 VDD VSS INVD1
XU2089 n3294 n3293 n3391 VDD VSS NR2D1
XU2090 n3635 n3636 n3637 VDD VSS AN2XD1
XU2091 n3294 n3293 n3595 VDD VSS ND2D1
XU2092 n3100 n2587 n2613 VDD VSS AN2D2
XU2093 n3713 n274 VDD VSS CKND2
XU2094 n3505 n3420 VDD VSS INVD1
XU2097 n3337 n1873 VDD VSS INVD4
XU2098 n1522 n3164 n3186 VDD VSS ND2D2
XU2099 n3557 n3285 n3466 n3297 n3468 VDD VSS FA1D2
XU2100 n2861 n2860 n2947 VDD VSS NR2XD3
XU2101 n3630 n277 VDD VSS INVD3
XU2102 n3062 n3061 n1723 VDD VSS CKND2D2
XU2103 n2946 n1551 VDD VSS CKND2
XU2104 n2861 n2860 n3689 VDD VSS ND2D4
XU2105 n1063 FE_OCPN1234_n3581 n1203 VDD VSS ND2D4
XU2106 n3285 FE_OCPN3459_n3557 n3310 n3309 n3311 VDD VSS FA1D1
XU2107 n2620 n1893 VDD VSS INVD1
XU2108 n939 n1847 n501 n500 VDD VSS OAI21D1
XU2109 n3635 n3620 VDD VSS BUFFD1
XU2110 n3550 n280 VDD VSS INVD6
XU2111 n938 n3435 n3441 VDD VSS ND2D1
XU2112 n2525 n2212 VDD VSS INVD1
XU2113 n859 n1371 VDD VSS INVD4
XU2114 n2847 n2845 VDD VSS CKND6
XU2115 n224 n3683 n3529 VDD VSS AN2D4
XU2116 n3285 FE_OCPN3459_n3557 n3465 n3469 n3308 VDD VSS FA1D1
XU2119 n922 n1115 n2811 VDD VSS CKND2D8
XU2120 n3208 n282 VDD VSS CKND2
XU2121 n2337 n3641 n3525 VDD VSS AN2XD1
XU2123 n2806 n2442 n1924 n2406 VDD VSS AOI21D1
XU2124 n3307 n3306 n2789 n3465 VDD VSS CKMUX2D1
XU2125 n459 n458 VDD VSS CKND2
XU2126 n2521 n2218 n2217 VDD VSS ND2D2
XU2127 n3286 n3263 VDD VSS INVD2
XU2129 n1119 n1892 n2614 VDD VSS ND2D3
XU2131 FE_OFN2773_n2601 n3092 n1990 n1989 VDD VSS OAI21D4
XU2132 FE_PSN1653_n2353 n2146 VDD VSS CKND2
XU2133 n3235 n1976 n1279 n2509 n1975 VDD VSS IAO22D2
XU2135 n2465 n1190 VDD VSS CKND4
XU2136 n1983 n3266 n91 n3099 VDD VSS MUX2D2
XU2137 n1977 n1993 n1976 VDD VSS CKND2D1
XU2138 n875 n964 n965 n1069 VDD VSS ND3D8
XU2139 n3705 n3079 n3078 n3077 n3131 VDD VSS OAI211D1
XU2141 n1935 n1936 n906 n3039 VDD VSS ND3D4
XU2142 n1736 n2528 VDD VSS INVD1
XU2144 n1710 n3060 n3059 VDD VSS INR2D1
XU2145 n3097 n1990 VDD VSS INVD2
XU2146 n1735 n2881 VDD VSS INVD2
XU2147 n422 n423 n798 n550 VDD VSS ND3D4
XU2148 n3561 n1566 n1482 VDD VSS IND2D1
XU2149 n2633 n2539 n2538 n2531 n2615 VDD VSS FA1D2
XU2150 n1392 n984 VDD VSS INVD1
XU2151 n2132 n1081 VDD VSS INVD2
XU2152 n2606 n2604 VDD VSS INVD1
XU2153 n2836 n1272 VDD VSS INVD1
XU2155 n460 n461 n457 VDD VSS AN2XD1
XU2156 n1372 n1745 n3286 VDD VSS IND2D4
XU2157 n2834 n2835 n385 VDD VSS ND2D2
XU2158 n3266 n100 n2243 n3261 VDD VSS OAI21D4
XU2159 n463 n462 n464 n459 VDD VSS ND3D1
XU2160 n649 n648 n650 VDD VSS ND2D1
XU2161 n3304 n3300 VDD VSS INVD1
XU2162 n2828 n2139 VDD VSS CKND2
XU2163 n3708 n3126 n3125 n3578 n3130 VDD VSS FA1D1
XU2164 n3076 n3075 n1864 n3074 n3077 VDD VSS OAI22D1
XU2165 n689 n686 n801 VDD VSS ND2D2
XU2166 n2522 n2216 VDD VSS CKND2
XU2167 n2466 n1187 VDD VSS INVD1
XU2168 n2409 n1509 VDD VSS INVD1
XU2169 n1717 n1977 VDD VSS INVD1
XU2170 n2679 n134 n2767 VDD VSS NR2XD2
XU2171 n2758 n1043 VDD VSS CKND2
XU2172 n2799 n2798 n2258 VDD VSS NR2XD0
XU2173 n2304 n3724 n3851 VDD VSS AN2D2
XU2174 n1410 n956 VDD VSS INVD1
XU2175 n2563 n1228 VDD VSS INVD1
XU2176 n2479 n2480 n2481 n3237 VDD VSS ND3D4
XU2177 n2651 n2650 n953 VDD VSS ND2D3
XU2178 n2199 n889 n982 VDD VSS ND2D3
XU2179 n337 n2687 n2744 VDD VSS CKND2D8
XU2180 n1979 n1096 VDD VSS INVD1
XU2182 n2540 n2579 n2300 n2543 VDD VSS OAI21D1
XU2183 n846 n1177 n845 VDD VSS CKND2D3
XU2184 n2479 n1974 VDD VSS INVD1
XU2185 n707 n1444 n1443 VDD VSS ND2D2
XU2188 n2572 n1891 n2576 VDD VSS ND2D1
XU2189 n1307 n1306 VDD VSS CKND2
XU2190 n602 n604 n2507 VDD VSS CKND2D2
XU2191 n1276 n1275 VDD VSS INVD2
XU2192 n2877 n1992 VDD VSS INVD4
XU2194 n2411 n1267 VDD VSS INVD1
XU2195 n1709 n2756 n2501 n2462 VDD VSS MUX2ND4
XU2196 n3023 n477 VDD VSS INVD1
XU2197 n1390 n1389 VDD VSS INVD1
XU2198 n2999 n467 VDD VSS INVD2
XU2199 n1801 n1790 n1109 VDD VSS ND2D4
XU2200 n1790 n2680 n2933 VDD VSS NR2D3
XU2201 n3032 n478 VDD VSS INVD1
XU2202 n3705 n3704 FE_OFN2780_y_22 n3707 VDD VSS AOI21D1
XU2204 n690 n2797 VDD VSS INVD1
XU2205 n2838 n2837 n3050 n2801 VDD VSS MUX2ND2
XU2208 n2504 n968 n2573 VDD VSS INR2XD4
XU2209 n3706 n2335 n3074 VDD VSS CKND2D2
XU2211 n1091 n2228 n3258 n1089 VDD VSS AOI21D2
XU2212 n1170 n1432 n1431 VDD VSS ND2D1
XU2214 n3531 n2267 n3532 VDD VSS ND2D4
XU2215 n593 n2670 n1493 VDD VSS ND2D4
XU2217 n925 n2246 n2248 VDD VSS CKND2D4
XU2218 n1985 n1320 VDD VSS INVD1
XU2219 n2425 n703 n1193 VDD VSS INR2XD0
XU2220 n1185 n1422 VDD VSS INVD1
XU2221 n2752 n2727 VDD VSS CKND3
XU2222 n100 n2627 n2631 VDD VSS ND2D1
XU2223 n2313 n1938 VDD VSS INVD1
XU2224 n1985 n1983 n1982 VDD VSS AN2XD1
XU2225 n2076 n371 n370 VDD VSS ND2D3
XU2226 n2090 n2909 n1958 VDD VSS AN2XD1
XU2227 n3157 n3027 VDD VSS INVD1
XU2228 n3834 n3835 VDD VSS INVD1
XU2230 n1077 n703 n1076 VDD VSS NR2XD2
XU2231 n3140 n3145 n3147 VDD VSS CKND2D2
XU2232 n2990 n2023 n628 VDD VSS CKND2D2
XU2233 n2923 n2922 n2290 VDD VSS NR2D1
XU2234 n3773 n3425 n3424 n3426 VDD VSS AOI21D1
XU2235 n2019 n2018 VDD VSS CKND4
XU2236 n903 n1237 n2994 n3030 VDD VSS ND3D4
XU2237 n736 n3063 n3064 VDD VSS ND2D1
XU2238 n3279 n318 n414 VDD VSS IND2D1
XU2239 n2995 n904 n2927 n2928 VDD VSS AOI21D1
XU2240 n2990 n2925 n2924 n1612 VDD VSS AOI21D1
XU2241 n894 n893 n3140 n3007 VDD VSS AN3XD1
XU2242 n2145 n2925 n1611 VDD VSS AN2D4
XU2243 n2570 n2588 n2571 VDD VSS AN2XD1
XU2244 n1491 n3106 n1217 VDD VSS ND2D4
XU2246 n2090 n1963 VDD VSS INVD2
XU2248 n2713 n2741 FE_OFN2743_y_20 n3522 VDD VSS MUX2ND0
XU2249 n2323 n671 VDD VSS INVD1
XU2251 n817 n816 VDD VSS INVD1
XU2252 n1572 n2569 n2588 VDD VSS ND2D1
XU2253 n3269 n3270 n3271 VDD VSS ND2D1
XU2254 n1572 n1956 VDD VSS INVD2
XU2255 n3439 n3762 n3440 VDD VSS CKND2D0
XU2256 n2996 n2995 n903 VDD VSS ND2D3
XU2259 n2150 n2149 n1234 n2591 VDD VSS IOA21D1
XU2261 n1222 n1221 VDD VSS CKND2
XU2262 n3014 n3013 n3157 VDD VSS CKND2D2
XU2263 n3058 FE_OFN2780_y_22 n736 VDD VSS CKND2D2
XU2264 n2333 n2720 n1920 VDD VSS ND2D2
XU2266 n3015 n1583 VDD VSS INVD0
XU2267 n961 n1018 n1968 VDD VSS CKND2D4
XU2268 FE_OFN1364_n1018 n2904 n2666 VDD VSS AN2XD1
XU2270 n2661 n2235 n1581 VDD VSS AN2D4
XU2271 n2594 n3067 VDD VSS BUFFD4
XU2272 n3766 n3425 VDD VSS INVD1
XU2273 n2430 n413 n412 VDD VSS ND2D3
XU2275 n2668 n2895 n2669 VDD VSS AN2D2
XU2276 n3111 n3191 n3112 VDD VSS XOR2D0
XU2277 n168 n1235 n1234 VDD VSS ND2D1
XU2278 n2086 n430 n2108 VDD VSS CKND2D4
XU2279 n3759 n3758 n3763 VDD VSS NR2XD0
XU2281 n3415 FE_OFN103_n3196 n3195 n3197 VDD VSS AO21D1
XU2282 FE_OFN3427_n2438 n3102 n3104 VDD VSS XOR2D0
XU2283 n389 n94 n388 VDD VSS NR2XD0
XU2284 n822 n3058 VDD VSS CKND2
XU2286 n2656 n2700 n2701 VDD VSS NR2XD1
XU2287 FE_OFN2754_x_18 FE_OFN102_n3172 n2512 VDD VSS XOR2D0
XU2289 FE_OCPN1153_n2688 n2247 VDD VSS CKND2
XU2293 FE_OFN3496_n261 n3299 n3302 VDD VSS ND2D1
XU2294 n2685 n1710 VDD VSS INVD4
XU2296 n1338 n1689 n2016 VDD VSS NR2D4
XU2297 n2871 n46 n1437 VDD VSS INR2XD0
XU2300 n96 n3428 n828 VDD VSS OR2D1
XU2301 n3006 n3005 n3144 VDD VSS CKND2D2
XU2302 FE_OFN102_n3172 n3171 n3402 VDD VSS NR2XD1
XU2305 FE_RN_210_0 y_mantissa[4] n430 VDD VSS ND2D4
XU2306 n3033 n3155 n3034 VDD VSS AN2D1
XU2307 n3025 n3142 n3026 VDD VSS AN2XD1
XU2308 n2926 n1930 VDD VSS CKBD1
XU2309 n2912 n1169 VDD VSS INVD2
XU2310 n2904 n1017 VDD VSS INVD1
XU2313 n2556 n309 VDD VSS INVD4
XU2314 n3036 n2453 VDD VSS CKND4
XU2315 n3114 n1579 n2508 VDD VSS IND2D1
XU2316 n3114 n293 n2503 VDD VSS XOR2D0
XU2317 n1687 n2487 n3179 VDD VSS NR2XD0
XU2320 n1711 n2782 n3012 VDD VSS NR2D8
XU2322 n2850 n317 VDD VSS INVD1
XU2323 n3603 n3582 VDD VSS BUFFD2
XU2326 n1710 n3098 VDD VSS BUFFD4
XU2329 n2786 n2125 VDD VSS INVD1
XU2331 n63 n1636 n3400 VDD VSS NR2D2
XU2352 n330 n2685 n334 VDD VSS ND2D4
XU2353 n338 n1863 n2739 VDD VSS ND2D8
XU2354 n222 n331 n336 VDD VSS ND2D4
XU2355 n1567 FE_OCPN3508_y_2 n2738 VDD VSS CKND2D8
XU2356 n335 n334 n337 VDD VSS ND2D8
XU2358 n337 n2687 n1620 VDD VSS NR2D8
XU2359 n338 n1922 VDD VSS INVD2
XU2361 n622 FE_OCPN1487_n2278 n1905 VDD VSS ND2D4
XU2362 n307 n339 n2359 VDD VSS INR2XD2
XU2364 n2696 n2686 n1904 VDD VSS CKND2D4
XU2365 n960 n818 n2665 VDD VSS AN2D4
XU2366 n1197 n2574 n1196 VDD VSS CKXOR2D1
XU2367 n740 n2754 n3047 VDD VSS NR2XD4
XU2369 n1369 n2515 n2209 n1207 VDD VSS OAI21D4
XU2370 FE_RN_152 n2433 VDD VSS CKND4
XU2372 n606 n157 n1869 VDD VSS ND2D3
XU2373 n2082 n80 n2118 VDD VSS INR2XD2
XU2374 n741 n2751 n772 VDD VSS ND2D3
XU2375 n3387 n374 n1068 VDD VSS CKND2D4
XU2376 csa_sum_1[12] csa_carry_1[12] n3387 VDD VSS ND2D4
XU2379 n344 n3628 n3868 VDD VSS NR2XD2
XU2382 n151 n614 VDD VSS INVD6
XU2383 n921 n2238 n541 VDD VSS CKND2D4
XU2384 n345 n1228 n1227 VDD VSS ND2D2
XU2385 n3729 FE_OCPN1566_n2677 n345 VDD VSS ND2D2
XU2387 n2014 n346 n558 VDD VSS CKND2D4
XU2388 n1938 n3002 n907 VDD VSS INR2D4
XU2389 n821 FE_OFN3427_n2438 n2483 VDD VSS CKXOR2D1
XU2390 n809 n808 n349 VDD VSS ND2D2
XU2391 n349 n1861 n539 VDD VSS NR2XD2
XU2392 n3583 FE_OCPN1289_n350 n3584 VDD VSS ND2D2
XU2393 n104 n2268 n1839 VDD VSS CKND2D2
XU2394 n104 n2207 n2095 VDD VSS NR2XD2
XU2395 n104 n2098 n2097 VDD VSS ND2D4
XU2396 n354 n353 VDD VSS INVD4
XU2397 FE_RN_87 FE_RN_136 n354 VDD VSS CKND2D8
XU2400 n1879 n2326 n362 VDD VSS XOR2D4
XU2401 n363 n2232 n1879 VDD VSS ND2D4
XU2404 n369 n264 n365 VDD VSS CKND2D4
XU2405 n366 n1529 n1945 VDD VSS ND2D4
XU2406 n368 n367 n366 VDD VSS ND2D4
XU2407 FE_RN_103 n3750 n369 VDD VSS ND2D4
XU2408 n613 n2002 n1773 VDD VSS ND2D8
XU2409 n372 n370 n613 VDD VSS ND2D4
XU2410 n373 FE_OFN2732_y_10 n372 VDD VSS ND2D2
XU2411 csa_sum_1[11] csa_carry_1[11] n374 VDD VSS ND2D4
XU2412 FE_OFN1369_n1851 n191 n376 VDD VSS ND2D8
XU2413 FE_OFN65_n378 n3696 n3697 n1498 VDD VSS AOI21D4
XU2415 n380 n248 n2113 n1383 VDD VSS AOI21D4
XU2416 FE_OFN66_n382 n1987 n3672 n1503 VDD VSS ND3D4
XU2417 FE_OFN66_n382 n3672 n2009 n1141 VDD VSS AOI21D4
XU2418 n208 FE_OFN66_n382 n1406 n1405 VDD VSS AOI21D4
XU2419 n2831 n2126 VDD VSS INVD6
XU2420 n2785 n1569 n383 VDD VSS ND2D4
XU2421 n3599 n1798 n1256 VDD VSS CKND2D3
XU2422 n219 n385 n2866 VDD VSS ND2D3
XU2423 n387 n386 n3570 VDD VSS NR2D4
XU2424 n2129 n2130 n387 VDD VSS ND2D4
XU2425 n3690 n2947 n3599 VDD VSS NR2XD4
XU2426 n2844 n1573 n388 n2860 VDD VSS AOI21D2
XU2427 n1059 n2843 n2861 VDD VSS ND2D4
XU2428 n2863 n2862 n3690 VDD VSS NR2D4
XU2429 n2271 n2273 n2863 VDD VSS CKND2D8
XU2430 n3048 n3581 n390 n2178 VDD VSS OAI21D4
XU2431 n1062 FE_OCPN1313_n390 n3049 VDD VSS ND2D4
XU2432 n537 n151 n536 VDD VSS ND2D4
XU2434 n393 n526 VDD VSS CKND4
XU2435 n258 n117 n1027 VDD VSS CKND2D4
XU2438 n166 n1644 n1502 VDD VSS INR2D4
XU2439 n185 n2476 n2101 n2480 VDD VSS ND3D4
XU2441 n1753 n2148 n3744 VDD VSS ND2D8
XU2444 n299 n2193 n3867 VDD VSS INR2XD2
XU2445 n614 FE_OCPN1296_n2751 n729 VDD VSS ND2D8
XU2446 n742 n743 n540 VDD VSS ND2D4
XU2447 n1503 n1957 VDD VSS CKND4
XU2448 n1357 n2811 n398 VDD VSS ND2D4
XU2449 FE_RN_64 n3640 n2157 VDD VSS XNR2D1
XU2450 n3275 n2017 VDD VSS INVD1
XU2452 n3007 n1022 n1527 VDD VSS ND2D3
XU2453 n2436 n613 n777 n2428 VDD VSS AOI21D2
XU2454 n1653 n3582 n858 VDD VSS ND2D4
XU2455 n1672 n846 VDD VSS CKND8
XU2456 n1845 n1118 VDD VSS INVD2
XU2458 n569 n406 base_plane[15] VDD VSS ND2D8
XU2463 n88 n410 VDD VSS BUFFD4
XU2465 n1639 n65 n2913 VDD VSS NR2D4
XU2466 n755 n762 VDD VSS CKND4
XU2467 n1967 n1966 n1691 VDD VSS ND2D4
XU2468 y_mantissa[7] n402 n2078 VDD VSS ND2D8
XU2470 n2244 FE_OCPN1320_n2206 n3363 VDD VSS ND2D1
XU2471 n3101 n3100 n1994 n3119 VDD VSS ND3D2
XU2473 n2882 n2881 n2880 VDD VSS NR2D4
XU2474 n778 n1148 n403 VDD VSS NR2XD4
XU2475 FE_RN_27 n1941 n1903 VDD VSS ND2D2
XU2476 n562 FE_RN_106 n1791 VDD VSS CKND2D4
XU2478 n2248 n951 n2137 VDD VSS ND2D3
XU2479 n770 n3616 n441 VDD VSS NR2D3
XU2480 n937 n3017 n3016 n568 VDD VSS AOI21D4
XU2483 n1802 n1109 n3743 VDD VSS ND2D4
XU2484 n3040 n905 n3543 VDD VSS CKND2D4
XU2486 n567 n3741 n406 VDD VSS CKND2D4
XU2488 n407 n2729 n615 VDD VSS ND2D4
XU2489 FE_RN_91 n965 n407 VDD VSS ND2D4
XU2490 n2660 n1165 n1967 VDD VSS ND2D8
XU2493 n3674 n2006 n3675 n3472 VDD VSS OAI21D4
XU2494 n1957 n1318 n2006 VDD VSS NR2D4
XU2496 csa_sum_1[23] csa_carry_1[23] n2886 VDD VSS NR2XD4
XU2500 n2527 n1534 VDD VSS CKND2
XU2503 n3642 n1508 n1507 VDD VSS NR2XD3
XU2504 n1880 n1881 n3038 VDD VSS CKND2D4
XU2507 n235 FE_RN_134 n670 VDD VSS NR2XD2
XU2508 n232 n3617 n1349 VDD VSS INR2XD4
XU2509 FE_RN_60 n1584 VDD VSS INVD4
XU2510 n411 n564 VDD VSS INVD4
XU2512 n915 n1435 n2677 VDD VSS ND2D4
XU2513 n540 n1430 n609 VDD VSS ND2D2
XU2514 n1114 n746 n742 VDD VSS CKND2D3
XU2515 n685 FE_RN_101 n682 VDD VSS ND2D4
XU2517 n1217 n1216 n2267 VDD VSS ND2D8
XU2519 n1849 n2153 n2269 VDD VSS ND2D8
XU2521 n2712 FE_RN_50 n733 VDD VSS ND2D4
XU2522 n3304 n3279 n416 VDD VSS CKXOR2D1
XU2523 n2652 FE_OFN3500_n2719 n2296 VDD VSS CKND2D8
XU2524 n119 n2536 n968 VDD VSS CKND2D8
XU2525 n3166 n2524 n2501 n2525 VDD VSS CKMUX2D1
XU2527 n1066 FE_RN_140 n421 VDD VSS CKND2D2
XU2528 n798 n2282 VDD VSS INVD4
XU2529 n420 n548 n2342 VDD VSS ND2D4
XU2530 n421 n420 VDD VSS CKND2
XU2531 n2283 n422 VDD VSS CKND2
XU2533 n1379 n425 VDD VSS INVD2
XU2534 n474 n475 n427 VDD VSS ND2D2
XU2535 n437 FE_OCPN1465_n430 n436 VDD VSS ND2D3
XU2536 n436 n433 n432 VDD VSS ND2D2
XU2537 n1462 n437 VDD VSS INVD2
XU2539 n1624 n1943 VDD VSS INVD6
XU2540 n1624 n2676 n2651 VDD VSS NR2XD2
XU2542 n1911 n2353 n2942 VDD VSS ND2D2
XU2543 n1733 n2225 n2821 VDD VSS ND2D4
XU2544 n932 n3232 n3292 VDD VSS CKND2D4
XU2545 n3018 n3140 VDD VSS CKND2
XU2546 n448 n446 n2827 VDD VSS NR2XD4
XU2547 n447 n1953 n446 VDD VSS NR2D4
XU2548 n449 n1717 n447 VDD VSS CKND2D4
XU2549 FE_RN_135 n2135 n1717 VDD VSS ND2D4
XU2550 n1718 n449 n262 n448 VDD VSS NR3D2
XU2551 n1947 n108 n449 VDD VSS INR2XD4
XU2552 n109 y_mantissa[9] n2918 VDD VSS NR2XD4
XU2553 n468 n483 n450 VDD VSS NR2XD1
XU2554 n453 n1901 n452 VDD VSS ND2D2
XU2555 n453 n2022 n474 VDD VSS CKND2D2
XU2556 n456 n3551 n1880 VDD VSS ND2D4
XU2557 n2173 n2941 n454 VDD VSS IND2D2
XU2558 n3037 n456 VDD VSS INVD4
XU2559 n463 n464 n3045 VDD VSS CKND2D3
XU2560 n458 n457 n3333 VDD VSS CKND2D4
XU2562 n467 n1022 n466 VDD VSS ND2D2
XU2563 n3039 n470 VDD VSS INVD2
XU2564 n250 n3039 n2349 VDD VSS ND2D3
XU2566 n941 FE_RN_82 n471 VDD VSS CKND2D2
XU2567 FE_OFN1364_n1018 FE_OCPN1496_n1760 n594 VDD VSS INR2D4
XU2568 FE_OCPN13_FE_OFN21_x_6 n99 n1018 VDD VSS CKND2D8
XU2570 n476 n1461 n3203 VDD VSS ND2D4
XU2571 n3045 n476 VDD VSS CKND2
XU2572 n3031 n480 VDD VSS INVD1
XU2573 n3032 n482 n481 VDD VSS AN2XD1
XU2574 n3034 n482 VDD VSS INVD1
XU2575 n1662 n484 n3547 VDD VSS ND2D3
XU2576 n2162 n484 n3553 VDD VSS CKND2D3
XU2578 n3447 n488 VDD VSS CKND2
XU2579 n998 n1690 n1779 n1183 VDD VSS OAI21D4
XU2581 n1786 n3812 n490 VDD VSS CKND2D2
XU2582 n1458 n1457 n497 VDD VSS ND2D2
XU2583 n495 n493 base_plane[23] VDD VSS ND2D3
XU2584 n494 FE_OFN2803_n2600 n493 VDD VSS CKND2D2
XU2586 n506 n226 n3806 VDD VSS ND2D2
XU2587 n500 n504 n3805 VDD VSS IND2D4
XU2588 n507 n511 n509 n506 VDD VSS IAO21D2
XU2589 n1470 n1469 n514 VDD VSS CKND2D2
XU2590 n514 n512 n270 n3780 n516 VDD VSS OAI22D2
XU2591 n516 n515 n3779 VDD VSS XNR2D1
XU2592 n1816 n3204 n3751 VDD VSS ND2D2
XU2596 n2338 n2161 n3550 VDD VSS CKND2D4
XU2597 n2085 n596 n1106 VDD VSS CKND2D8
XU2598 n3330 n1791 n525 n596 VDD VSS AOI21D4
XU2601 n527 selected_delta_1[5] VDD VSS CKND4
XU2603 n3582 n533 n528 VDD VSS INR2XD2
XU2604 n530 n535 n529 VDD VSS CKND2D2
XU2605 n1063 FE_RN_46 n535 VDD VSS CKND2D2
XU2607 csa_sum_1[7] csa_carry_1[7] n2117 VDD VSS ND2D3
XU2610 n542 n958 VDD VSS INVD6
XU2611 n544 FE_OFN3412_n2730 n2963 VDD VSS ND2D4
XU2613 n1817 FE_RN_25_0 n1429 VDD VSS ND2D3
XU2614 n1033 FE_RN_25_0 n697 VDD VSS IND2D2
XU2615 n557 n2444 n549 VDD VSS CKND2D4
XU2617 n187 n2047 FE_OCPN1505_FE_OFN112_n2457 n552 VDD VSS AOI21D4
XU2618 FE_RN_30 n298 n988 VDD VSS CKND2D3
XU2620 n553 n1109 n1129 VDD VSS CKND2D4
XU2621 n555 n193 n1041 n843 VDD VSS IOA21D4
XU2622 FE_RN_114 n2012 n2444 VDD VSS NR2D4
XU2623 n1802 n1249 n1148 VDD VSS ND2D3
XU2624 n560 n3327 n561 VDD VSS ND2D4
XU2626 n1751 n1750 n1016 VDD VSS ND2D3
XU2627 n1249 n1801 n1790 n675 VDD VSS ND3D4
XU2628 n1650 n75 n3478 VDD VSS ND2D3
XU2632 n575 n574 n572 n1756 VDD VSS ND3D2
XU2633 FE_OFN2803_n2600 n573 n572 VDD VSS INR2D2
XU2634 n577 n3371 n573 VDD VSS NR2D2
XU2635 n576 n3371 n577 n574 VDD VSS ND3D2
XU2636 n1634 x_mantissa[16] n3138 VDD VSS NR2XD1
XU2637 n2293 FE_OCPN1508_n592 n3185 VDD VSS NR2D3
XU2638 n3349 n3543 n582 VDD VSS AN2XD1
XU2639 n588 n988 n590 VDD VSS ND2D2
XU2641 n1168 n2462 n3630 VDD VSS NR2XD2
XU2642 n2755 n590 n1168 VDD VSS CKND2D4
XU2643 n1456 FE_OFN101_n3160 n1674 VDD VSS NR2D4
XU2645 n2293 n592 n2327 VDD VSS IND2D4
XU2646 n1593 n1592 n940 VDD VSS ND2D4
XU2648 n1494 n1495 n593 VDD VSS ND2D4
XU2649 n2906 FE_OFN1364_n1018 n1017 n1495 VDD VSS AOI21D4
XU2653 n2892 n2893 n595 VDD VSS NR2D8
XU2654 n3810 FE_OFN98_n300 n1808 VDD VSS IND2D2
XU2656 n2590 n2839 n2274 VDD VSS INR2D4
XU2657 n598 n2476 n2275 n2839 VDD VSS AOI21D4
XU2658 n698 FE_OFN2804_y_13 n1671 VDD VSS CKND2D8
XU2660 n2680 n1658 n1802 VDD VSS ND2D4
XU2661 FE_OFN1355_n605 n2328 n1890 VDD VSS CKND2D2
XU2662 FE_OFN1355_n605 n1044 n721 VDD VSS ND2D4
XU2663 FE_OFN68_n605 n3248 n1885 VDD VSS CKND2D1
XU2666 n730 n608 n1927 VDD VSS ND2D4
XU2667 n610 n1086 VDD VSS CKND4
XU2668 n2274 n610 n2273 VDD VSS CKND2D2
XU2669 n1034 n2270 n610 VDD VSS CKND2D4
XU2671 n3600 n3601 n1829 VDD VSS ND2D3
XU2672 n1381 n2864 n3600 VDD VSS ND2D4
XU2673 n613 n2594 n2427 VDD VSS NR2XD1
XU2674 n615 n2962 VDD VSS INVD1
XU2675 FE_OCPN1412_n615 FE_OCPN1441_n1069 n885 VDD VSS ND2D3
XU2676 n2752 n304 n616 VDD VSS NR2D3
XU2677 n618 n617 n2752 VDD VSS ND2D4
XU2678 n2665 n1719 n619 VDD VSS XNR2D4
XU2679 n1780 n2441 n1066 VDD VSS ND2D4
XU2680 n2222 n1333 n1067 VDD VSS ND2D3
XU2681 n271 n88 n3750 n621 VDD VSS ND3D2
XU2683 n625 n3146 n3148 VDD VSS CKND2D4
XU2684 n359 n626 n625 VDD VSS ND2D2
XU2685 n3147 n626 VDD VSS CKND2
XU2687 n203 n628 n3022 VDD VSS ND2D3
XU2688 n328 FE_OFN73_n2417 n2926 VDD VSS CKXOR2D4
XU2690 n2349 n2365 n3336 VDD VSS ND2D3
XU2691 n630 n1926 n2365 VDD VSS ND2D4
XU2692 n2171 n630 VDD VSS CKND4
XU2694 n631 FE_OFN3426_n2438 n3288 VDD VSS XOR2D4
XU2695 n2395 n634 n633 n632 VDD VSS NR3D2
XU2697 n1506 n3240 FE_OFN3425_n2438 n636 VDD VSS AOI21D4
XU2698 n638 n1505 n637 VDD VSS CKND2D4
XU2699 n639 n3638 n3659 VDD VSS ND2D4
XU2700 n640 n639 VDD VSS CKND4
XU2701 n2961 n641 n640 VDD VSS IND2D4
XU2702 n2026 n2958 n641 VDD VSS ND2D2
XU2703 n3446 n3510 n3514 n642 n3447 VDD VSS OAI211D4
XU2704 n1781 n3442 n3515 VDD VSS ND2D2
XU2705 n2597 n2689 n645 n2602 VDD VSS OA21D2
XU2706 n57 FE_OFN1360_n647 n2105 n951 VDD VSS AOI21D4
XU2707 n646 n1319 n3266 VDD VSS CKND2D4
XU2708 n1982 n925 n646 VDD VSS ND2D2
XU2709 FE_OFN1360_n647 n925 VDD VSS INVD4
XU2710 n664 n1875 n90 n659 VDD VSS OA21D1
XU2711 FE_OCPN1526_n1748 n1747 n1786 VDD VSS ND2D4
XU2712 n667 n899 n898 VDD VSS CKND2D2
XU2713 n901 n668 n667 VDD VSS ND2D2
XU2715 csa_sum_1[9] csa_carry_1[9] n669 VDD VSS CKND2D8
XU2716 n3551 n2352 n670 n1317 VDD VSS AOI21D2
XU2718 n675 n1016 n1544 VDD VSS CKND2D1
XU2719 n1149 n1248 n3327 VDD VSS ND2D4
XU2720 n1392 n676 n3666 VDD VSS INR2D4
XU2722 n678 n2794 n3664 VDD VSS ND2D4
XU2723 n2167 FE_PSN1654_n1924 n680 VDD VSS ND2D2
XU2724 n1143 n1142 n2169 VDD VSS ND2D8
XU2725 n681 FE_OCPN1548_n2793 n2982 VDD VSS ND2D4
XU2726 n683 n2043 n681 VDD VSS ND2D2
XU2728 FE_RN_5 n2985 VDD VSS CKND2
XU2729 n693 n691 selected_delta_2[10] VDD VSS NR2XD2
XU2730 FE_OCPN1591_n2986 n1344 n70 n692 VDD VSS AOI21D1
XU2731 n2777 FE_OFN2727_shared_plane_25 n2649 VDD VSS CKND2D1
XU2732 n1138 n698 VDD VSS CKND4
XU2733 n240 FE_OCPN1199_n1138 n2272 VDD VSS CKND2D1
XU2734 FE_RN_131 n1064 n1078 VDD VSS NR2D8
XU2739 n2459 n1072 n1501 VDD VSS ND2D4
XU2740 n1388 n704 VDD VSS INVD0
XU2741 n706 n705 VDD VSS INVD0
XU2742 FE_RN_50 n3234 n731 VDD VSS CKND2D4
XU2743 n853 n707 VDD VSS INVD2
XU2746 n711 n710 n1606 VDD VSS ND2D4
XU2748 n3477 FE_OCPN1204_n3352 n711 VDD VSS ND2D4
XU2749 n714 n3695 n713 VDD VSS CKND2D4
XU2750 n1231 n197 n714 VDD VSS ND2D3
XU2751 n721 n720 n2026 VDD VSS ND2D3
XU2752 n716 n715 n3847 VDD VSS NR2D3
XU2753 n719 n717 n721 n718 n716 VDD VSS OAI22D2
XU2755 n725 FE_OCPN3462_n1646 n1525 VDD VSS ND2D4
XU2756 n725 n2241 FE_OCPN3462_n1646 n1614 VDD VSS ND3D4
XU2757 n726 FE_OFN2768_n2447 n2155 VDD VSS IND2D4
XU2758 n820 n1131 n726 VDD VSS CKND2D4
XU2759 n728 n3626 n2001 VDD VSS NR2D8
XU2760 FE_RN_49 n728 VDD VSS INVD12
XU2763 n734 n2974 n2979 n1283 VDD VSS ND3D2
XU2765 n3719 n738 n2315 VDD VSS INR2XD2
XU2767 n1995 n1996 n1420 VDD VSS CKND2D8
XU2768 n1329 n212 n1996 VDD VSS NR2XD4
XU2769 FE_OCPN1251_n3494 FE_OCPN1205_n2117 n3495 VDD VSS ND2D2
XU2771 n741 n2018 n2014 VDD VSS NR2XD3
XU2772 n741 n1333 VDD VSS CKND6
XU2774 n746 n262 n745 n1430 VDD VSS OAI21D4
XU2775 n2229 FE_OCPN1514_n877 n745 VDD VSS NR2XD2
XU2778 n754 n3346 n2111 n752 VDD VSS OAI21D1
XU2779 n3344 n754 VDD VSS INVD1
XU2780 n756 n759 n758 n755 VDD VSS ND3D2
XU2781 n227 n3216 FE_RN_62 n758 VDD VSS ND3D3
XU2782 n760 n3741 n759 VDD VSS ND2D2
XU2784 n761 FE_OCPN1185_n3745 n1145 n2306 n760 VDD VSS OAI22D2
XU2786 n236 FE_OCPN1296_n2751 n764 VDD VSS ND2D4
XU2787 n1133 n3103 FE_OCPN1431_n766 n1131 VDD VSS ND3D4
XU2788 n2821 n248 n3617 VDD VSS ND2D4
XU2789 n2078 n2077 VDD VSS INVD12
XU2792 n1870 n1583 n773 VDD VSS ND2D2
XU2793 n1785 n1784 n3335 VDD VSS NR2XD2
XU2796 n1648 n836 n2934 VDD VSS ND2D4
XU2797 n2934 n2935 n2937 VDD VSS NR2XD4
XU2798 n1014 n199 n1853 VDD VSS ND2D4
XU2800 n3726 n1421 n3728 VDD VSS CKND2D2
XU2801 FE_OCPN1267_n864 n1504 n1517 VDD VSS ND2D4
XU2802 n1138 FE_OFN2805_y_13 n1670 VDD VSS ND2D4
XU2803 n1556 n1557 n1559 VDD VSS ND2D2
XU2805 n1405 n3594 n1404 VDD VSS XNR2D4
XU2807 n1029 n1807 n1806 VDD VSS ND2D2
XU2808 n3480 n1359 n1776 n2373 VDD VSS OAI21D4
XU2809 csa_sum_1[14] csa_carry_1[14] n1776 VDD VSS ND2D4
XU2810 csa_sum_1[14] csa_carry_1[14] n3480 VDD VSS NR2XD4
XU2811 n1001 n1000 n2938 VDD VSS ND2D8
XU2812 n1277 n2151 n1276 VDD VSS ND2D2
XU2814 n3683 n1356 n3859 VDD VSS INR2XD2
XU2815 n3626 n1519 n2460 VDD VSS ND2D8
XU2816 n3686 n2292 VDD VSS INVD1
XU2817 n882 n2464 n782 n3217 VDD VSS AOI21D4
XU2819 n1316 n1943 n2676 n928 VDD VSS OAI21D4
XU2820 n1220 n1219 n2768 VDD VSS ND2D4
XU2821 n1912 n1304 VDD VSS CKND4
XU2822 n784 FE_OFN3419_n3224 n3852 VDD VSS NR2D4
XU2824 FE_RN_34 n3733 n954 VDD VSS NR2D8
XU2825 n787 FE_OCPN1268_n288 n2058 VDD VSS CKXOR2D4
XU2826 n1441 n1446 n1442 n787 VDD VSS ND3D2
XU2827 n3700 n3699 n3698 n788 VDD VSS OA21D1
XU2829 n278 n1370 n1208 n3643 VDD VSS AOI21D4
XU2830 n3012 n3151 n2390 VDD VSS CKND2D3
XU2831 n2857 n2856 n3567 VDD VSS NR2D8
XU2836 n792 n947 VDD VSS INVD4
XU2838 n2533 n3608 n2617 VDD VSS NR2XD2
XU2839 FE_OCPN1212_n3365 n1020 n3366 VDD VSS ND2D2
XU2842 n2433 n1983 n1811 VDD VSS ND2D4
XU2843 n85 n797 VDD VSS INVD8
XU2844 n2289 n62 n1883 VDD VSS IND2D4
XU2845 n2221 n2855 n3686 VDD VSS NR2XD2
XU2846 n1056 n2257 n1031 VDD VSS CKND2D4
XU2847 n1630 n195 n1037 VDD VSS ND2D8
XU2850 n2114 n1716 VDD VSS INVD4
XU2852 n1043 n1523 n859 VDD VSS INR2D4
XU2853 n2006 n3677 n2104 VDD VSS XNR2D4
XU2854 FE_OFN108_n2450 n2295 n2776 n1252 VDD VSS ND3D8
XU2855 n917 n2149 n2123 VDD VSS ND2D4
XU2856 n1615 n3422 n803 VDD VSS NR2D1
XU2857 n3421 n804 VDD VSS INVD1
XU2858 n2294 n3361 n3364 VDD VSS NR2D8
XU2860 n3328 n3327 n3331 VDD VSS ND2D3
XU2861 n3735 n3734 n3736 VDD VSS ND2D2
XU2864 n3480 n2049 n2374 VDD VSS NR2XD2
XU2865 n217 n1282 n811 n1369 VDD VSS AOI21D4
XU2867 n815 n814 n1419 VDD VSS ND2D2
XU2868 n2466 n2465 n3635 VDD VSS ND2D3
XU2869 n181 n2836 VDD VSS CKND4
XU2870 n3266 n2102 n3199 n3274 VDD VSS INR3D4
XU2871 n1037 n2250 n1274 VDD VSS ND2D4
XU2872 n2410 n2409 n2945 VDD VSS CKND2D3
XU2874 n1914 FE_RN_31 n1629 VDD VSS ND2D8
XU2876 n58 n1758 VDD VSS INVD8
XU2877 n2658 n935 VDD VSS CKND2
XU2878 n824 n3540 n1785 VDD VSS NR2XD2
XU2879 n1649 n3016 VDD VSS INVD1
XU2880 n164 n2699 n2894 VDD VSS NR2XD2
XU2882 n2173 n2941 n2339 VDD VSS ND2D8
XU2883 n1056 FE_OCPN1473_n2760 n1041 VDD VSS ND2D4
XU2885 n1948 n3703 n1665 VDD VSS ND2D2
XU2887 n826 n1596 n2561 VDD VSS ND2D4
XU2888 FE_RN_1 n2383 n2382 n2884 VDD VSS OAI21D4
XU2889 n2474 n2205 n2481 VDD VSS ND2D1
XU2890 n1123 y_mantissa[14] n3151 VDD VSS NR2D4
XU2894 csa_sum_1[20] n1102 VDD VSS INVD4
XU2896 n830 n110 n1899 VDD VSS ND2D4
XU2898 n832 n831 n3856 VDD VSS NR2XD2
XU2899 FE_RN_21 n2902 n1277 VDD VSS ND2D2
XU2900 n2665 n2440 VDD VSS INVD2
XU2901 n3048 n3047 n2074 VDD VSS NR2XD2
XU2902 n866 n865 n3494 VDD VSS ND2D8
XU2903 n834 n833 n2362 VDD VSS NR2XD2
XU2904 FE_OFN2725_n107 n3107 n3098 n2869 VDD VSS ND3D4
XU2905 n1685 n2746 n2596 n2747 VDD VSS MUX2D2
XU2906 n1757 n2943 base_plane[11] VDD VSS ND2D8
XU2908 n2675 n2678 n3734 VDD VSS CKND2D4
XU2910 n3733 n3735 VDD VSS CKND4
XU2912 n2665 n2753 n1049 VDD VSS CKND2D4
XU2914 n2460 n2700 VDD VSS INVD1
XU2916 n842 n841 n840 VDD VSS CKND2D4
XU2917 FE_OCPN1411_n3330 n841 VDD VSS INVD4
XU2919 n944 n943 VDD VSS CKND6
XU2920 n858 n857 n3855 VDD VSS NR2XD4
XU2922 n1879 n1465 n1662 VDD VSS CKXOR2D4
XU2925 n1543 n2659 n1302 VDD VSS ND2D3
XU2927 n1300 FE_OCPN1492_n2686 n1165 VDD VSS CKND2D4
XU2928 n1424 n1423 VDD VSS CKND2
XU2929 n1565 n2616 n2615 n2545 n2620 VDD VSS FA1D1
XU2932 n3240 n2431 n1505 VDD VSS NR2XD4
XU2933 n1076 n1773 FE_OCPN1489_FE_RN_12 n1075 VDD VSS ND3D3
XU2934 n173 n3834 n3326 VDD VSS CKND2D2
XU2935 n3362 n2208 n2294 VDD VSS INR2XD2
XU2936 n152 n850 VDD VSS INVD2
XU2937 FE_RN_47 n851 n3583 n1007 VDD VSS OAI21D4
XU2938 FE_OCPN1459_FE_OFN23_x_4 FE_OCPN1228_n1251 n2659 VDD VSS ND2D3
XU2940 n2129 n2133 n2130 n1381 VDD VSS ND3D4
XU2941 n1083 n1082 n2129 VDD VSS ND2D4
XU2942 n2064 n1664 n854 n2119 VDD VSS IOA21D2
XU2943 n1663 n2765 n854 VDD VSS ND2D2
XU2944 n2762 n1726 FE_OFN2735_x_9 n3050 n2735 VDD VSS OAI22D4
XU2945 n2096 n2095 n3865 VDD VSS NR2XD4
XU2946 n1241 n3361 VDD VSS INVD1
XU2947 n855 n856 n1860 VDD VSS NR2D8
XU2948 csa_sum_1[11] n1104 VDD VSS INVD4
XU2949 n1104 n1824 n3485 VDD VSS ND2D4
XU2950 n67 FE_OCPN8_y_0 n1686 VDD VSS NR2D8
XU2953 FE_RN_48 n864 n3520 n1826 VDD VSS AOI21D4
XU2954 n3116 n2279 n1264 n3379 VDD VSS AOI21D4
XU2957 n3584 n1826 n2060 VDD VSS XNR2D4
XU2961 n870 FE_OCPN1598_n2467 n3622 VDD VSS ND2D2
XU2962 n871 n870 n3621 VDD VSS INR2XD4
XU2964 n2467 n871 VDD VSS INVD4
XU2966 csa_sum_1[2] csa_carry_1[2] n3365 VDD VSS ND2D8
XU2968 n874 n2948 n1653 VDD VSS CKND2D4
XU2969 n3573 n874 n1215 VDD VSS ND2D3
XU2970 FE_OCPN1520_n3599 n1830 n152 n1827 VDD VSS ND3D3
XU2971 n963 n1027 n221 n1333 n875 VDD VSS AOI22D4
XU2974 n1742 FE_OCPN3440_n1078 n1823 VDD VSS ND2D4
XU2977 n1136 n882 n1135 VDD VSS XNR2D2
XU2978 n252 n846 n1029 VDD VSS CKND2D2
XU2979 n252 n846 n1700 n1804 VDD VSS ND3D2
XU2980 n2072 n1337 n888 VDD VSS ND2D4
XU2981 FE_RN_109 n1792 n887 VDD VSS ND2D8
XU2982 n888 n1336 n2012 VDD VSS CKND2D8
XU2983 FE_RN_152 n326 n2724 n3305 n2730 VDD VSS OAI22D2
XU2985 n1370 n213 n3642 VDD VSS ND2D4
XU2987 n2406 n2405 n2181 n2415 VDD VSS OAI21D4
XU2988 n1785 n1784 n1649 VDD VSS NR2D3
XU2989 n2913 n2912 n2145 VDD VSS NR2D4
XU2990 n898 n896 n1819 VDD VSS ND2D2
XU2991 n901 n668 n897 n896 VDD VSS ND3D2
XU2992 n2930 n465 n2994 VDD VSS ND2D1
XU2993 n3039 n905 VDD VSS CKND4
XU2994 n3002 n1412 n907 n906 VDD VSS AOI21D4
XU2995 n911 n909 n2240 n2857 VDD VSS ND3D8
XU2996 n910 n913 n909 VDD VSS ND2D4
XU2997 n1782 n910 VDD VSS INVD4
XU2998 n3785 n1782 n912 n123 n911 VDD VSS OAI211D4
XU2999 n2114 n1715 VDD VSS INVD4
XU3000 n1594 n914 VDD VSS CKND4
XU3001 n86 FE_OCPN3441_n2086 n1594 VDD VSS ND2D4
XU3002 n915 n2562 n1421 VDD VSS ND2D4
XU3003 n2561 n915 VDD VSS CKND4
XU3005 n920 n2404 n1924 VDD VSS CKND2D8
XU3006 n1671 n303 n1670 n920 VDD VSS ND3D8
XU3007 n2822 n2823 n3231 VDD VSS NR2XD2
XU3010 FE_RN_38 n2561 n1316 VDD VSS CKND2D4
XU3011 n1320 n1677 n1729 n1319 VDD VSS OAI21D2
XU3012 n2071 FE_OFN106_n1673 n1677 VDD VSS ND2D8
XU3013 n3393 n3595 n3394 n2009 VDD VSS OAI21D4
XU3014 n930 n3295 n3394 VDD VSS ND2D4
XU3015 n3393 n3391 n3672 VDD VSS NR2XD2
XU3016 n3292 n1350 VDD VSS INVD6
XU3017 n2827 n2143 n931 VDD VSS ND2D2
XU3018 n283 n2140 n932 VDD VSS ND2D4
XU3020 n3750 n88 n1548 VDD VSS CKND2D1
XU3021 n1184 n936 n1469 VDD VSS ND2D3
XU3022 n2093 n2092 n937 VDD VSS ND2D8
XU3025 n2450 n994 n948 VDD VSS XOR2D4
XU3026 FE_OCPN1583_n92 FE_RN_12 n1185 VDD VSS CKND2D2
XU3027 n3339 n3338 n3337 n3340 VDD VSS OAI21D4
XU3029 n1440 n2650 n952 VDD VSS CKND2D4
XU3030 n253 FE_OFN2809_shared_plane_22 n2809 VDD VSS CKND2D1
XU3031 FE_OCPN1567_n2195 FE_OCPN1472_n2731 n1410 VDD VSS ND2D2
XU3032 n1335 FE_RN_37 n957 VDD VSS ND2D3
XU3033 n2469 n2468 n3219 VDD VSS ND2D2
XU3034 n1075 n2446 n959 VDD VSS ND2D3
XU3035 n1631 n473 n2664 VDD VSS INR2D2
XU3036 FE_OCPN3515_FE_OFN21_x_6 FE_RN_121 FE_OCPN3457_x_5 n1760 VDD VSS AOI21D4
XU3037 n1333 n966 n963 VDD VSS CKND2D4
XU3038 n1868 n1306 n965 VDD VSS ND2D3
XU3040 n967 n2647 n1265 VDD VSS CKND2D3
XU3041 n1375 n3276 n3254 VDD VSS NR2XD2
XU3042 n971 n979 n3048 VDD VSS NR2D8
XU3043 n972 n1023 VDD VSS INVD6
XU3044 csa_sum_1[3] csa_carry_1[3] n972 VDD VSS ND2D4
XU3045 n242 n973 n1140 VDD VSS ND2D2
XU3046 n1407 n3673 n973 n1406 VDD VSS OAI21D2
XU3048 n974 n1053 VDD VSS CKND12
XU3049 n1645 n1026 n976 VDD VSS ND2D2
XU3050 n253 FE_OFN2750_shared_plane_6 n1514 mantissa_value[6] VDD VSS IOA21D4
XU3052 FE_RN_20 FE_OCPN1270_n3387 n3388 VDD VSS ND2D1
XU3053 csa_carry_1[12] n978 VDD VSS INVD6
XU3054 n2220 n981 VDD VSS CKND2
XU3055 n2963 FE_OCPN1203_n982 n1105 VDD VSS CKND2D1
XU3056 FE_OFN2731_y_21 n2832 n985 VDD VSS INR2D2
XU3059 n3641 n1334 n2356 VDD VSS INR2XD2
XU3061 n2705 n797 n2707 n797 n989 VDD VSS MAOI22D1
XU3063 n1056 n1071 n993 VDD VSS ND2D2
XU3064 n156 n995 n1604 VDD VSS CKND2D2
XU3065 n3803 n997 VDD VSS INVD1
XU3066 n1874 n3339 n3342 n1872 n1690 VDD VSS OAI211D4
XU3067 n1873 n2327 n1872 VDD VSS ND2D4
XU3068 n1001 n1000 n1876 n3215 VDD VSS ND3D2
XU3069 n3283 n3438 n1002 n3295 VDD VSS AOI21D4
XU3071 n1004 n1071 VDD VSS INVD6
XU3074 FE_RN_14 n2385 n2384 n1008 VDD VSS AOI21D4
XU3075 n189 n1695 n1011 n2844 VDD VSS OAI21D4
XU3076 FE_OCPN1148_n2899 n2672 n1014 VDD VSS ND2D4
XU3077 n2939 n2940 n3214 VDD VSS ND2D4
XU3078 n1021 n3384 n3365 n3498 VDD VSS OAI21D4
XU3079 csa_sum_1[2] csa_carry_1[2] n1021 VDD VSS NR2D8
XU3080 csa_sum_1[3] n1025 VDD VSS INVD4
XU3081 n2702 n1032 n2755 VDD VSS CKND2D4
XU3082 n2851 n1034 VDD VSS CKND6
XU3083 n1206 n2411 n3644 VDD VSS ND2D4
XU3085 n2759 n1042 VDD VSS INVD4
XU3086 n3656 n1046 n1044 VDD VSS INR2D2
XU3087 n2510 n1071 n1055 VDD VSS INR2XD2
XU3088 FE_RN_32 n1057 VDD VSS INVD4
XU3089 n2039 n1860 n1058 VDD VSS CKND2D4
XU3090 n1061 n1060 n1059 VDD VSS ND2D2
XU3091 n1782 n1716 n252 n1061 VDD VSS ND3D2
XU3092 n3048 n1062 VDD VSS CKND4
XU3093 n2053 n1070 n2052 VDD VSS ND2D4
XU3094 n317 n1071 n2257 VDD VSS INR2XD2
XU3095 n2156 n1072 VDD VSS INVD1
XU3096 n3621 n3635 n1074 VDD VSS NR2D3
XU3097 n2832 n95 n1080 n2864 VDD VSS AOI21D4
XU3098 n1086 n1085 n1084 VDD VSS ND2D8
XU3099 n2227 n2228 n1091 n1090 VDD VSS ND3D1
XU3102 n289 n180 n1092 VDD VSS INR2D4
XU3103 n1697 n1096 n1093 n2873 VDD VSS OAI21D4
XU3104 n1095 n1094 n1697 n1093 VDD VSS IOA21D4
XU3105 n2867 n1095 VDD VSS INVD1
XU3106 n2016 n1099 VDD VSS CKND6
XU3107 FE_OFN2739_x_10 FE_OFN59_n180 n2494 VDD VSS NR2XD2
XU3109 n3362 n1241 n2766 VDD VSS ND2D2
XU3110 n1102 n1101 n3362 VDD VSS CKND2D4
XU3111 n2592 n2629 n1233 VDD VSS CKXOR2D1
XU3112 n1103 n2002 n2627 n3299 n2592 VDD VSS AOI22D4
XU3113 n2588 n2589 n1103 VDD VSS CKXOR2D1
XU3114 n3552 FE_OCPN1395_n1106 n1163 VDD VSS IND2D4
XU3115 n3228 n1107 n1198 VDD VSS ND2D2
XU3116 n2530 n2529 n3612 VDD VSS ND2D3
XU3117 n1108 n2062 n3228 VDD VSS CKND2D4
XU3118 n2531 n1108 VDD VSS CKND2
XU3120 x_mantissa[1] n2694 n1112 VDD VSS IND2D2
XU3121 n2576 n2629 n1120 VDD VSS CKXOR2D1
XU3122 FE_OFN3425_n2438 n2534 FE_OCPN3443_n58 n2574 VDD VSS MUX2ND4
XU3123 n1124 n1123 n2250 VDD VSS ND2D4
XU3124 n2392 FE_OFN106_n1673 n1124 VDD VSS CKND2D4
XU3125 n2785 n1728 n2482 n52 n2401 VDD VSS OAI22D4
XU3126 n2394 n52 FE_OFN106_n1673 n1125 VDD VSS ND3D8
XU3129 n1134 n1133 VDD VSS CKND4
XU3130 n1135 n3628 n2299 VDD VSS NR2XD4
XU3131 n277 FE_OCPN1555_n3629 n1136 VDD VSS AN2XD1
XU3135 n320 n1139 n2343 VDD VSS INR2XD2
XU3138 n1952 n2139 n2143 VDD VSS ND2D4
XU3140 n2562 n1435 VDD VSS CKND6
XU3141 n2037 FE_OCPN1281_n1150 n3378 VDD VSS CKND2D4
XU3143 n2767 n1152 VDD VSS INVD2
XU3144 n1156 n1155 n1154 n1661 VDD VSS AOI21D4
XU3145 FE_OCPN1541_n1617 n1157 VDD VSS INVD2
XU3146 n3727 n3726 n1158 VDD VSS ND2D3
XU3147 n1162 n1161 n1160 VDD VSS ND2D2
XU3148 n1967 n1966 n1898 VDD VSS ND2D8
XU3149 n2938 n1166 n2161 VDD VSS CKND2D4
XU3150 n1876 n1166 VDD VSS CKND6
XU3151 n1754 n3611 n3610 n1167 VDD VSS AOI21D4
XU3152 n1476 n1475 n120 n2840 VDD VSS MUX2D4
XU3153 n2838 n2400 n121 n2837 VDD VSS MUX2ND2
XU3154 n3449 FE_RN_147 n1181 n1180 n3450 VDD VSS OAI211D4
XU3155 n3449 n1182 n1181 VDD VSS ND2D2
XU3156 n1184 n1945 n1468 VDD VSS ND2D2
XU3159 n115 n3161 n1473 VDD VSS CKND2D4
XU3160 n1190 n1187 n3636 VDD VSS CKND2D4
XU3162 n1422 n2423 n1193 n1192 VDD VSS ND3D2
XU3163 n2574 n304 n1195 VDD VSS IND2D1
XU3164 n3228 n3613 n2533 VDD VSS ND2D3
XU3165 n1199 n1771 n2618 VDD VSS CKND2D4
XU3166 n3582 n1202 n3846 VDD VSS INR2XD2
XU3167 n1207 n2412 n3647 VDD VSS ND2D2
XU3168 n1205 n1267 n3646 VDD VSS ND2D4
XU3169 n1212 n1211 n1210 VDD VSS ND2D2
XU3170 n2297 n2637 n3321 n1211 VDD VSS AOI21D1
XU3171 n2026 n266 n2297 n1212 VDD VSS ND3D1
XU3172 n1214 n1213 n3246 VDD VSS ND2D2
XU3174 n1215 n1291 VDD VSS INVD2
XU3176 n2553 n1223 VDD VSS INVD6
XU3177 n3533 n3535 n3534 n3727 VDD VSS OAI21D4
XU3179 n1229 n1230 n3729 VDD VSS ND2D4
XU3180 n2559 n1438 n2560 n1230 VDD VSS OAI21D4
XU3182 n3282 n1576 n2569 VDD VSS XNR2D1
XU3183 n1238 n2111 n2041 VDD VSS ND2D2
XU3184 n1240 n1239 n1870 VDD VSS ND2D4
XU3185 FE_OFN2798_n3030 n3152 n3157 n1239 VDD VSS AOI21D2
XU3186 n3345 n1784 VDD VSS CKND4
XU3187 n2171 n3041 n3345 VDD VSS IND2D4
XU3189 n1254 n465 n1253 VDD VSS ND2D4
XU3190 n2728 n3661 VDD VSS INVD2
XU3191 n1257 n260 n3662 VDD VSS ND2D2
XU3192 n1258 n3517 n2230 VDD VSS ND2D4
XU3194 n1260 n1896 n1259 VDD VSS CKND2D4
XU3195 n1690 n1262 n1261 n1260 VDD VSS OAI21D2
XU3196 n1900 n1895 n1262 VDD VSS NR2D2
XU3197 n1263 n3117 n3381 VDD VSS NR2D4
XU3198 n872 n1699 n2024 VDD VSS ND2D8
XU3199 n1727 n2803 n2868 VDD VSS CKXOR2D4
XU3200 n2837 n1574 n1268 n2411 VDD VSS OAI21D2
XU3201 FE_OCPN1291_n2785 n1274 n1746 VDD VSS ND2D8
XU3203 n1746 n3517 n2804 n1281 VDD VSS ND3D2
XU3205 n1291 n1289 n1290 VDD VSS CKND2D3
XU3206 n72 n1738 n1294 n1737 VDD VSS OAI21D4
XU3207 n1295 n225 selected_delta_2[11] VDD VSS NR2XD2
XU3208 n3456 n1298 n3457 n2379 VDD VSS OAI21D4
XU3209 n1463 n1612 n1303 VDD VSS CKND2D4
XU3210 n1597 n1308 VDD VSS CKND2
XU3211 n3217 n1332 n1331 n1597 VDD VSS OAI21D1
XU3213 n2384 n1311 VDD VSS INVD2
XU3214 n3591 n3673 n1987 VDD VSS NR2D3
XU3215 n3470 n1318 n2005 n2004 VDD VSS AOI21D4
XU3220 FE_RN_85 n2472 n2471 n1563 VDD VSS OAI21D4
XU3221 n1997 n3696 n1777 VDD VSS ND2D1
XU3224 n3663 n2007 n2174 n1352 VDD VSS AOI21D4
XU3225 n703 n312 n1353 VDD VSS AN2XD1
XU3227 n2551 FE_OCPN1226_n1359 n2552 VDD VSS CKND2D3
XU3229 n3683 n1362 n1655 VDD VSS INR2D4
XU3230 n1365 n2983 n1424 VDD VSS CKND2D2
XU3231 n1365 n2983 n2103 n1425 VDD VSS OAI21D2
XU3232 n2800 n2801 n2812 VDD VSS NR2D4
XU3233 n2260 n1368 n1367 n1366 n2800 VDD VSS OAI211D4
XU3234 n2258 n181 n1366 VDD VSS CKND2D1
XU3235 n180 FE_OFN3496_n261 n1368 VDD VSS XNR2D4
XU3236 n1370 n2945 n2946 VDD VSS CKND2D1
XU3237 n1510 n1509 n1370 VDD VSS ND2D4
XU3239 n2295 n1630 n1378 VDD VSS ND2D1
XU3241 n2618 n1379 n2546 VDD VSS CKND2D2
XU3243 n3039 n3040 n3540 VDD VSS CKND2D4
XU3244 n2831 n1236 n2132 VDD VSS ND2D4
XU3247 FE_RN_78 n2981 n1391 VDD VSS NR2XD2
XU3248 n1399 n2147 VDD VSS CKND2
XU3249 n2000 n68 n1399 VDD VSS CKND2D2
XU3250 n2525 n2526 n3649 VDD VSS ND2D4
XU3251 n2516 n2517 n2514 n2183 n1400 VDD VSS MAOI22D1
XU3252 n320 n1404 n3853 VDD VSS INR2XD2
XU3253 n2009 n1407 VDD VSS CKND4
XU3254 n1408 n3619 n2331 VDD VSS NR2D8
XU3255 n1590 n3494 n2368 VDD VSS CKND2D4
XU3256 FE_OFN2799_n3030 n2393 n3001 n3002 VDD VSS AOI21D4
XU3257 n3336 n3338 n1414 VDD VSS NR2XD1
XU3258 n3340 n3343 n1415 VDD VSS CKND2D2
XU3259 FE_OFN1333_n1420 n3723 n3722 n3725 VDD VSS AOI21D0
XU3260 n1421 n1617 VDD VSS INVD4
XU3261 n1425 n1423 n3864 VDD VSS NR2XD2
XU3262 n1435 FE_OCPN1453_n2561 n3726 VDD VSS ND2D4
XU3263 FE_RN_88 n2874 n3222 VDD VSS NR2D4
XU3264 csa_sum_1[10] csa_carry_1[10] n3490 VDD VSS ND2D4
XU3265 csa_sum_1[10] csa_carry_1[10] n3489 VDD VSS NR2XD4
XU3266 csa_sum_1[9] csa_carry_1[9] n3500 VDD VSS NR2XD4
XU3267 n2966 n1439 VDD VSS INVD1
XU3268 n853 n1444 n2712 n1441 VDD VSS ND3D1
XU3269 n2712 n1448 VDD VSS CKND2
XU3270 n61 n105 n1676 VDD VSS CKND2D8
XU3271 n3380 n3381 n1453 VDD VSS NR2D4
XU3272 n1455 n1454 FE_OFN3417_n3224 selected_delta_1[11] VDD VSS AOI21D4
XU3273 FE_RN_26 n1599 n1454 VDD VSS CKND2D4
XU3274 n3777 n284 n3802 VDD VSS ND2D1
XU3275 FE_RN_147 n3818 n1458 VDD VSS ND2D2
XU3276 n3777 n284 n3804 VDD VSS NR2XD1
XU3277 FE_OCPN1510_n3729 n3728 n3730 VDD VSS CKXOR2D1
XU3278 n2607 n2629 n2611 VDD VSS XNR2D1
XU3279 n2573 n1459 n2629 VDD VSS ND2D2
XU3280 n2574 n2150 n1459 VDD VSS AN2XD1
XU3281 n2882 n2881 n3115 VDD VSS ND2D3
XU3282 n2874 n2875 n3223 VDD VSS ND2D4
XU3283 n1460 n2657 n1585 VDD VSS CKND2D4
XU3284 n2652 n1462 n2109 VDD VSS NR2D8
XU3285 n3448 n1467 VDD VSS INVD0
XU3286 n284 n3448 n3781 VDD VSS ND2D1
XU3287 n1471 n3158 n3160 VDD VSS ND2D4
XU3288 FE_OCPN1515_n2840 n1726 n68 n3289 n2794 VDD VSS OAI22D4
XU3291 FE_OCPN1137_shared_plane_26 FE_OCPN1491_n3519 n2389 VDD VSS CKND2D1
XU3292 n1479 FE_RN_3 n1478 VDD VSS ND2D2
XU3293 n3501 FE_RN_3 shared_plane[9] VDD VSS XNR2D2
XU3294 n1723 n1484 n1480 VDD VSS CKND2D0
XU3295 n1722 n1484 n1481 VDD VSS CKND2D0
XU3296 n1723 n1485 n3133 VDD VSS CKXOR2D1
XU3297 n3711 n1485 n3322 VDD VSS CKXOR2D1
XU3298 n1566 n3561 n1485 VDD VSS XNR2D1
XU3299 n1486 n200 n3561 VDD VSS ND2D2
XU3300 csa_sum_1[26] csa_carry_1[26] n2949 VDD VSS NR2D4
XU3301 n1995 n1996 n3718 n1488 VDD VSS ND3D4
XU3302 n1488 n1489 n3565 VDD VSS ND2D3
XU3303 n3719 n1490 n3861 VDD VSS INR2XD2
XU3304 n3565 n3462 n1490 VDD VSS CKXOR2D1
XU3306 divided_plane[22] n239 n1528 VDD VSS CKND2D4
XU3307 n3536 n2560 n3537 VDD VSS CKXOR2D1
XU3308 n1496 FE_OCPN1191_n3534 n3536 VDD VSS ND2D3
XU3309 n3717 n1497 n3845 VDD VSS INR2D4
XU3311 n1957 n3470 n2003 VDD VSS ND2D2
XU3312 n3520 n1504 VDD VSS INVD4
XU3314 n2413 n2219 VDD VSS INVD0
XU3315 n2410 n1510 VDD VSS INVD3
XU3317 n1773 n1808 n1700 VDD VSS ND2D8
XU3318 n1515 n1123 n3154 VDD VSS ND2D1
XU3319 n1516 n310 n2340 VDD VSS NR2XD4
XU3322 n2718 FE_RN_210_0 n2086 VDD VSS CKND2D4
XU3323 n2419 n2734 n2912 VDD VSS NR2D3
XU3324 n1527 n1531 n1526 VDD VSS CKND2D3
XU3325 n1639 n1707 n2914 VDD VSS CKND2D4
XU3326 n1639 FE_OCPN1256_n2907 n2172 VDD VSS CKND2D4
XU3328 FE_OFN2785_n3022 n3140 n3144 n1531 VDD VSS AOI21D2
XU3329 n109 n1519 n2892 VDD VSS NR2XD3
XU3330 n2787 n2455 n2451 VDD VSS INR2XD1
XU3332 n2216 n1279 n2214 n1535 n2213 VDD VSS AOI22D2
XU3333 n1697 FE_OCPN1232_n1746 n1535 VDD VSS NR2D4
XU3336 n2363 n1615 n1550 VDD VSS INR2D2
XU3337 n3508 n1553 n1554 VDD VSS CKND2D1
XU3338 n1552 n3507 n1555 VDD VSS ND2D2
XU3339 n3507 n1553 VDD VSS INVD0
XU3340 n3099 n1094 n3095 VDD VSS XNR2D1
XU3341 n2057 n2830 n1558 VDD VSS ND2D2
XU3342 n2057 n1556 VDD VSS CKND2
XU3343 n2830 n1557 VDD VSS INVD1
XU3345 n3397 n2262 n2344 VDD VSS INR2XD2
XU3346 csa_sum_1[23] csa_carry_1[23] n2887 VDD VSS ND2D4
XU3348 n1910 FE_RN_93 n3547 n1909 VDD VSS OAI21D4
XU3349 n290 n3021 n3024 VDD VSS ND2D1
XU3350 n3018 n3139 n3021 VDD VSS NR2D1
XU3354 FE_OCPN1393_n3350 n3477 VDD VSS CKND8
XU3355 n2937 n2933 n3329 VDD VSS NR2D4
XU3356 FE_OFN70_n1339 n3083 n2245 VDD VSS NR2D4
XU3357 n3083 n728 n1923 VDD VSS NR2XD4
XU3359 n1749 n3417 n3442 VDD VSS CKXOR2D2
XU3362 n1814 n1587 n1588 VDD VSS ND2D2
XU3363 n3102 n298 n3082 VDD VSS IND2D2
XU3364 n3126 n3120 VDD VSS INVD1
XU3365 n2024 n2187 n2107 VDD VSS ND2D2
XU3366 n2713 n2492 n2309 VDD VSS AN2XD1
XU3367 FE_OCPN1495_n1916 n941 n2492 VDD VSS NR2XD1
XU3368 n3011 n2796 VDD VSS INVD1
XU3369 n3149 n1022 n1592 VDD VSS ND2D2
XU3370 n3148 n1593 VDD VSS INVD3
XU3371 n895 n3147 n3149 VDD VSS NR2D2
XU3372 n3220 n1598 VDD VSS INVD1
XU3373 n2346 FE_OCPN1485_n3219 n3220 VDD VSS ND2D1
XU3374 n2842 n1710 n2081 VDD VSS IND2D2
XU3377 n3743 n1601 VDD VSS CKND2
XU3378 n179 divided_plane[17] FE_OFN3478_FE_OFN3423_n1728 mantissa_value[17]
+ VDD VSS MUX2D4
XU3379 n238 n3621 n3218 VDD VSS NR2XD2
XU3380 n3178 n3177 n3206 VDD VSS CKXOR2D4
XU3381 n2918 n2917 n2993 VDD VSS NR2XD2
XU3382 n2918 n2902 VDD VSS INVD1
XU3383 n3419 n3503 VDD VSS INVD1
XU3384 n2434 n1848 VDD VSS CKND2
XU3385 csa_carry_1[11] csa_sum_1[11] n3484 VDD VSS ND2D1
XU3386 n2972 FE_RN_95 n2971 n2974 VDD VSS AOI21D2
XU3387 n1623 n313 n2319 VDD VSS NR2XD2
XU3389 n2479 n2480 n2481 n1627 VDD VSS ND3D4
XU3390 n3049 FE_OCPN1234_n3581 n2027 VDD VSS CKND2D2
XU3391 n3218 n2346 n2472 VDD VSS CKND2D3
XU3393 n2510 n2439 n2298 VDD VSS AN2D4
XU3394 csa_sum_1[22] csa_carry_1[22] n1646 VDD VSS CKND2D4
XU3395 n3706 n3704 VDD VSS INVD1
XU3396 n1853 n1647 n1648 VDD VSS ND2D2
XU3398 n3730 n302 n3731 VDD VSS ND2D2
XU3399 FE_OCPN1409_csa_sum_1_15 FE_PSN1647_csa_carry_1_15 n1650 VDD VSS OR2D4
XU3400 n2948 n1652 VDD VSS INVD2
XU3401 n3689 n2947 n2948 VDD VSS INR2D4
XU3402 n2715 n1849 VDD VSS BUFFD8
XU3403 n163 divided_plane[15] FE_OFN3488_n3837 mantissa_value[15] VDD VSS
+ MUX2D4
XU3404 n2998 FE_OFN2786_n3022 n2997 n1939 VDD VSS AOI21D2
XU3405 FE_OFN3418_n3224 n1980 n3860 VDD VSS INR2XD4
XU3407 n3487 FE_OCPN1178_n3485 n3386 n2065 VDD VSS AOI21D4
XU3408 FE_OCPN1445_n62 n3002 n2313 n1935 VDD VSS ND3D2
XU3409 n3442 n3445 VDD VSS INVD1
XU3410 n2840 n2408 VDD VSS CKND1
XU3411 n2765 n1664 VDD VSS INVD2
XU3413 n3601 n1666 VDD VSS INVD2
XU3416 n3376 n3377 VDD VSS CKND2
XU3417 n2420 n55 n1740 VDD VSS NR2D2
XU3418 n2401 n2402 VDD VSS CKND1
XU3419 n2469 n2468 n2346 VDD VSS OR2D4
XU3420 n2415 n2414 n3639 VDD VSS ND2D4
XU3422 n1992 n256 n1991 n3097 VDD VSS OAI21D4
XU3424 n3480 n3481 VDD VSS INVD0
XU3425 n1676 n2015 n2127 VDD VSS CKND2D1
XU3426 n1676 n2128 VDD VSS INVD0
XU3427 n1630 n105 n2853 VDD VSS ND2D4
XU3429 n184 n2478 n3109 VDD VSS NR2D3
XU3430 shared_plane[18] n1678 VDD VSS INVD0
XU3431 n1678 n1679 VDD VSS INVD0
XU3435 n1998 n1683 VDD VSS INVD0
XU3436 n180 n2799 n2260 VDD VSS NR2XD1
XU3437 n181 n2852 n2048 VDD VSS ND2D2
XU3438 n57 n3162 n2247 n2105 VDD VSS IOA21D2
XU3439 n3238 n2101 n3196 VDD VSS IND2D1
XU3440 y_mantissa[16] y_mantissa[15] n3155 VDD VSS CKND2D1
XU3442 FE_OCPN1478_FE_OFN51_y_6 n807 n2699 VDD VSS NR2D3
XU3445 n3685 n1692 VDD VSS INVD1
XU3446 n3685 n1693 VDD VSS INVD1
XU3448 n2831 n168 n2280 VDD VSS NR2XD2
XU3450 n1697 n2515 n2209 VDD VSS CKND2D2
XU3452 n2901 n101 n2919 VDD VSS ND2D4
XU3453 n1768 FE_OFN71_n1563 n1767 VDD VSS NR2XD1
XU3454 n3659 selected_delta_3[28] VDD VSS CKND4
XU3455 n2833 n2832 n2523 n2409 VDD VSS MUX2ND0
XU3456 n1705 n3110 FE_OFN17_x_12 n1632 n2535 VDD VSS ND4D2
XU3457 n1700 n2850 n1807 VDD VSS NR2D2
XU3459 n3027 n1701 n3154 n3028 VDD VSS OAI21D1
XU3460 n291 n1701 n3029 VDD VSS NR2D2
XU3461 FE_OFN2724_n107 FE_OFN109_n251 n2215 VDD VSS ND2D1
XU3465 n1398 n2824 n3171 VDD VSS NR2D1
XU3467 n3791 n1706 VDD VSS INVD2
XU3469 n348 n2748 n1861 VDD VSS CKND2D2
XU3470 n2685 n2748 VDD VSS INVD2
XU3471 shared_plane[21] n1712 VDD VSS INVD0
XU3472 FE_OFN1366_n1641 n1916 n2658 VDD VSS NR2D4
XU3473 n2137 n2135 n1718 VDD VSS CKND2D4
XU3474 n1718 n2499 n2517 VDD VSS NR2D3
XU3475 n1718 n2514 VDD VSS CKND2
XU3477 n2907 FE_OCPN3515_FE_OFN21_x_6 n2495 VDD VSS NR2D1
XU3478 n3562 n3561 n1723 n3135 n3563 VDD VSS FA1D0
XU3479 n3322 n3713 n3324 VDD VSS OR2XD1
XU3485 n2226 n2807 n2820 VDD VSS ND2D2
XU3486 FE_OFN2753_x_18 n1737 FE_OFN3480_n46 n1735 VDD VSS MUX2ND0
XU3487 FE_OFN2753_x_18 n1737 n2501 n1736 VDD VSS MUX2ND0
XU3488 n2984 n1741 selected_delta_2[23] VDD VSS INR2D2
XU3489 n3679 n3313 n1741 VDD VSS XNR2D1
XU3490 n2003 n2004 n3679 VDD VSS ND2D3
XU3491 FE_OFN2794_n1743 n2806 n2168 VDD VSS NR2D0
XU3492 n3442 n3444 n3505 VDD VSS ND2D1
XU3495 n2180 n307 n3230 VDD VSS CKND2D3
XU3496 n2944 n3748 n1757 VDD VSS ND2D4
XU3497 n1759 n1758 n3083 n1919 VDD VSS OA21D4
XU3499 n1764 FE_OFN71_n1563 n1770 n1763 VDD VSS ND3D3
XU3500 n2110 n305 n2112 n3757 base_plane[6] VDD VSS OAI22D4
XU3501 n3481 FE_OCPN1180_n1776 n3482 VDD VSS CKND2D2
XU3502 n3093 n3092 n3091 FE_OFN2802_x_22 n2200 VDD VSS OAI22D2
XU3503 n2102 n2002 n2203 n3284 VDD VSS AOI21D4
XU3506 n1793 n3431 n3776 VDD VSS CKXOR2D1
XU3507 n270 n2358 n3783 n3812 VDD VSS AOI21D2
XU3508 n3600 n3574 n3575 n1796 VDD VSS OAI21D4
XU3511 n3569 n3568 n1813 VDD VSS ND2D4
XU3512 csa_sum_1[6] csa_carry_1[6] n1815 VDD VSS ND2D4
XU3513 n1819 n2111 n1818 VDD VSS CKND2D4
XU3515 n1836 n1831 selected_delta_1[17] VDD VSS NR2XD2
XU3516 n1411 n1519 n2893 VDD VSS NR2D8
XU3518 n1843 n3658 n2355 VDD VSS NR2XD4
XU3521 n322 n1847 VDD VSS CKND2
XU3522 n1003 FE_OCPN1600_n3275 n2852 n239 n3279 VDD VSS AOI22D1
XU3523 n3186 n3332 n3750 VDD VSS NR2D4
XU3524 FE_RN_15 n3496 VDD VSS INVD4
XU3525 n3456 n3453 n2380 VDD VSS NR2D4
XU3528 n2739 n1862 VDD VSS INVD4
XU3530 n2530 n1866 VDD VSS CKND4
XU3531 n1867 n2212 n2348 VDD VSS ND2D3
XU3533 n1897 n3511 n1896 VDD VSS NR2XD1
XU3534 n1691 n2709 n2678 VDD VSS XNR2D4
XU3535 n3509 n1901 VDD VSS CKND4
XU3536 n3753 n3374 n3509 VDD VSS CKND2D3
XU3537 shared_plane[5] n253 n1907 mantissa_value[5] VDD VSS IOA21D2
XU3538 n1965 FE_OFN1383_n2906 FE_OCPN1546_n1964 n1913 VDD VSS AOI21D4
XU3540 n1918 n1921 n3526 VDD VSS ND2D4
XU3541 n1920 n1919 n1918 VDD VSS CKND2D2
XU3543 n2675 n1929 VDD VSS INVD4
XU3544 n3121 n1931 n3059 n3062 VDD VSS OAI21D2
XU3546 csa_sum_1[27] csa_carry_1[27] n2976 VDD VSS NR2XD2
XU3547 n1937 n1936 VDD VSS CKND2
XU3548 FE_OCPN1461_n113 n2313 n3003 n1937 VDD VSS NR3D1
XU3549 FE_RN_118 n1942 VDD VSS CKND4
XU3551 n3237 n1956 n1955 VDD VSS CKXOR2D2
XU3552 n3097 n3235 FE_OFN2726_n107 n3108 VDD VSS ND3D2
XU3553 n3237 n3235 VDD VSS INVD4
XU3554 csa_sum_1[19] csa_carry_1[19] n3456 VDD VSS NR2XD4
XU3556 n2880 n3115 n2254 VDD VSS IND2D4
XU3557 n2578 n821 n1993 n3100 VDD VSS ND3D1
XU3558 n3560 n2006 n3559 n3684 VDD VSS OA21D1
XU3560 n2025 n3409 n3444 VDD VSS XOR2D2
XU3561 n2029 n3678 n2321 VDD VSS NR2D8
XU3562 FE_OFN107_n1696 n2391 n2392 VDD VSS NR2XD2
XU3563 FE_OFN107_n1696 n2393 n2394 VDD VSS NR2D8
XU3565 n3206 n2035 VDD VSS CKND2
XU3566 n3551 n2036 VDD VSS INVD2
XU3567 n249 n2364 n3502 VDD VSS ND2D3
XU3569 n3204 n2046 VDD VSS CKND2
XU3570 n2444 FE_OFN3428_n2438 n2222 VDD VSS NR2D4
XU3571 n2083 FE_OCPN1220_n2781 n2265 VDD VSS NR2XD1
XU3572 n3367 n2368 n2367 n3488 VDD VSS OAI21D4
XU3573 n3416 n3411 n3768 VDD VSS CKND2D2
XU3574 n3122 n254 n3056 VDD VSS CKXOR2D1
XU3575 n2051 n185 n3122 VDD VSS INR2XD2
XU3576 n3445 n3444 n3514 VDD VSS ND2D1
XU3577 n2052 n2263 n2057 VDD VSS ND2D4
XU3578 FE_RN_2 n2372 n2371 n2550 VDD VSS OAI21D4
XU3580 n2058 n3528 n2317 VDD VSS NR2XD4
XU3581 n2770 n2769 n2771 VDD VSS CKXOR2D4
XU3583 n2060 FE_OFN3417_n3224 n3850 VDD VSS NR2XD4
XU3584 n2532 n2062 VDD VSS CKND4
XU3585 n3782 n3783 VDD VSS INVD1
XU3586 n3772 n3794 VDD VSS INVD1
XU3589 n2866 n2865 n3575 VDD VSS ND2D2
XU3591 n2741 n326 n2713 n2733 n2722 VDD VSS OAI22D4
XU3592 n2636 n2635 n2957 VDD VSS NR2D2
XU3594 n3473 n2984 n2361 VDD VSS AN2D4
XU3595 n3045 n3044 n3337 VDD VSS ND2D2
XU3598 n2081 n73 n2843 VDD VSS CKND2D1
XU3600 n1638 FE_OCPN1460_n2094 n2449 VDD VSS CKXOR2D1
XU3601 n2477 n2100 n2205 VDD VSS ND2D2
XU3602 n3196 n2100 VDD VSS CKND2
XU3604 n2104 n314 n2360 VDD VSS NR2XD2
XU3605 FE_OCPN1493_n3670 n2113 VDD VSS INVD1
XU3606 FE_OCPN1205_n2117 n2194 VDD VSS INVD2
XU3607 n154 n1539 n3368 VDD VSS CKND2D1
XU3609 n2131 n2280 n2130 VDD VSS NR2XD4
XU3610 FE_RN_135 n2135 n2826 VDD VSS ND2D3
XU3611 n3206 n3207 n2364 VDD VSS IND2D4
XU3614 n2491 n3090 n2158 VDD VSS AN2D4
XU3615 n1662 n2162 VDD VSS CKND2
XU3616 n3749 n3748 n2163 VDD VSS ND2D4
XU3617 n2806 n324 n2166 VDD VSS INR2XD0
XU3618 n3541 FE_OCPN1590_n2366 n3332 VDD VSS ND2D3
XU3621 n2200 n3120 n3588 VDD VSS ND2D2
XU3622 FE_OFN3481_n59 n2790 n2203 VDD VSS AN2XD1
XU3623 n2205 n3054 VDD VSS CKND2
XU3624 n3455 n2380 n2379 n2208 VDD VSS AOI21D4
XU3625 n1722 n3127 n3702 VDD VSS ND2D1
XU3628 n3641 n2223 selected_delta_3[2] VDD VSS INR2XD2
XU3629 n2231 n2230 base_plane[20] VDD VSS ND2D4
XU3630 n473 n1685 n2235 VDD VSS ND2D8
XU3631 n2857 n2856 n3568 VDD VSS ND2D2
XU3632 n257 add_x_7_B_19_ n2243 VDD VSS ND2D1
XU3633 n2244 FE_RN_98 n2383 VDD VSS CKND2D4
XU3634 n2392 FE_OCPN1181_FE_OFN105_n1078 n2835 VDD VSS CKND2D3
XU3635 csa_sum_1[17] csa_carry_1[17] n2261 VDD VSS ND2D4
XU3636 n3531 n2266 VDD VSS INVD0
XU3637 csa_sum_1[15] csa_carry_1[15] n3354 VDD VSS NR2D4
XU3638 n2931 n186 n2270 VDD VSS INR2XD2
XU3640 n89 FE_OCPN1287_shared_plane_20 n2276 VDD VSS CKND2D0
XU3641 n2285 n3628 selected_delta_3[6] VDD VSS NR2XD4
XU3642 csa_sum_1[19] csa_carry_1[19] n3457 VDD VSS ND2D4
XU3643 n2550 n2374 n2373 n3350 VDD VSS AOI21D4
XU3644 n3274 n3273 n3272 n3557 VDD VSS AOI21D4
XU3645 n2689 n293 n2300 VDD VSS OR2D0
XU3646 n2303 FE_OFN1349_FE_RN_56 n2304 VDD VSS AN2XD1
XU3648 n3137 n3719 n2310 VDD VSS AN2D4
XU3649 n3246 n3244 n2325 VDD VSS AN2XD1
XU3650 FE_OCPN3509_y_2 n2416 n2332 VDD VSS CKND2D2
XU3651 n2890 n176 n2335 VDD VSS CKND2D1
XU3652 FE_OCPN1504_n3523 n3522 n2336 VDD VSS OR2D0
XU3653 n3524 n2336 n2337 VDD VSS CKAN2D0
XU3654 n2496 n2495 n2354 VDD VSS AN2D2
XU3658 n3558 n1981 n2357 VDD VSS AN2XD1
XU3659 x_mantissa[20] n2438 VDD VSS CKND4
XU3664 n3815 n3816 VDD VSS INVD0
XU3665 n2987 n2925 VDD VSS INVD1
XU3666 FE_OFN3410_n2609 FE_OFN2744_y_20 n2610 VDD VSS IND2D1
XU3667 n298 n3105 n3870 n3118 VDD VSS MUX2ND2
XU3668 FE_OFN3422_shared_plane_3 divided_plane[3] n3836 mantissa_value[3] VDD
+ VSS MUX2D4
XU3669 FE_OFN2765_shared_plane_9 divided_plane[9] n3835 mantissa_value[9] VDD
+ VSS MUX2D4
XU3670 FE_OFN2771_shared_plane_13 divided_plane[13] n3835 mantissa_value[13]
+ VDD VSS MUX2D4
XU3672 n3500 n3489 n2370 VDD VSS NR2XD4
XU3673 n3356 n3354 n3352 VDD VSS NR2XD3
XU3676 n67 FE_OCPN3505_y_0 n2719 VDD VSS NR2XD8
XU3677 n3012 n2786 n2391 VDD VSS CKND2D1
XU3685 n1727 n2498 n2396 VDD VSS XOR2D0
XU3687 n48 n181 n2398 VDD VSS CKND2D0
XU3689 FE_OFN59_n180 n2399 n2400 VDD VSS CKXOR2D1
XU3691 n100 FE_OFN2805_y_13 n2404 VDD VSS ND2D2
XU3692 n2515 FE_RN_133 n2405 VDD VSS NR2D2
XU3693 n2420 n1100 n2421 VDD VSS CKXOR2D1
XU3694 n58 n2583 VDD VSS BUFFD2
XU3695 n2583 FE_OFN2732_y_10 n2425 VDD VSS ND2D1
XU3696 n2427 n2423 VDD VSS CKND2
XU3697 n2425 n3065 n2426 VDD VSS ND2D1
XU3698 FE_OCPN1153_n2688 n2540 VDD VSS BUFFD4
XU3700 n2220 n2724 VDD VSS INVD0
XU3704 n2493 n2713 FE_OCPN1586_n2686 n1729 n2445 VDD VSS AOI31D2
XU3705 n2445 n1631 n2447 VDD VSS XNR2D1
XU3707 FE_OFN2735_x_9 n2762 n2595 n2463 VDD VSS MUX2ND4
XU3711 n2439 n2461 VDD VSS CKND2
XU3712 n2715 n2476 VDD VSS INVD1
XU3714 n57 n2878 VDD VSS INVD1
XU3715 n1642 n2485 n2490 VDD VSS ND2D1
XU3716 n2485 n1642 n2486 VDD VSS NR2D1
XU3717 n2516 n821 n2183 n2491 VDD VSS ND3D2
XU3718 n3008 n328 n2497 VDD VSS NR2XD2
XU3719 n1633 x_mantissa[9] n2496 VDD VSS NR2D0
XU3720 FE_OFN3430_n2438 FE_OFN2744_y_20 n2500 VDD VSS IND2D1
XU3721 n2871 n1579 n3114 n2502 VDD VSS ND3D0
XU3722 n2508 n2507 n2506 n2505 n2538 VDD VSS OAI211D4
XU3723 n1627 FE_OFN3430_n2438 n2509 VDD VSS NR2XD0
XU3724 n1627 FE_OFN3426_n2438 n2511 VDD VSS CKXOR2D1
XU3727 n1279 n2517 n2518 VDD VSS CKND2D1
XU3728 FE_OFN2725_n107 n2510 n2522 VDD VSS ND2D1
XU3730 n1984 n1729 n2579 VDD VSS ND2D2
XU3731 n3261 n2877 n2101 n2593 VDD VSS ND3D1
XU3732 n2593 n2541 VDD VSS INVD1
XU3735 n2549 selected_delta_3[17] VDD VSS CKND6
XU3737 n2049 n2551 VDD VSS INVD1
XU3741 n2568 n1728 n2572 VDD VSS CKND2D1
XU3743 n2569 n3106 n2570 VDD VSS OR2D0
XU3744 n1731 FE_OFN2780_y_22 n2596 n2582 n2597 VDD VSS FA1D0
XU3745 n2515 n2602 n2603 VDD VSS INR2D1
XU3746 n2879 n2604 n2603 n2605 VDD VSS AOI21D2
XU3747 n2626 n3250 VDD VSS INVD1
XU3748 n2631 n2630 n2523 n2640 VDD VSS MUX2ND2
XU3749 n3212 n2637 VDD VSS INVD1
XU3750 n2640 n2641 VDD VSS INVD1
XU3751 n2642 n2641 n2959 VDD VSS ND2D1
XU3753 n2646 n2645 n2647 VDD VSS ND2D1
XU3754 n2656 n2667 n2657 VDD VSS ND2D3
XU3756 n2893 n2668 VDD VSS INVD0
XU3757 n2779 n2896 n2674 VDD VSS ND2D2
XU3758 n2933 n2682 VDD VSS INVD1
XU3759 n2936 n2681 VDD VSS INVD0
XU3761 n2555 FE_OCPN3509_y_2 n2691 VDD VSS ND2D4
XU3762 n2628 FE_OCPN3509_y_2 n2690 VDD VSS CKND2D8
XU3765 n1709 n3305 n2707 VDD VSS CKND2D1
XU3766 n2220 n1709 n2705 VDD VSS NR2XD0
XU3768 n58 n1759 n2716 VDD VSS CKND2D2
XU3770 n2777 n2720 VDD VSS CKND4
XU3773 n2748 n2850 VDD VSS CKND4
XU3774 n1638 n2762 n95 n2764 VDD VSS MUX2ND4
XU3775 FE_OCPN1254_n2845 FE_OCPN1229_n2846 n2765 VDD VSS ND2D4
XU3777 n120 FE_OFN2741_x_11 n2774 VDD VSS CKXOR2D1
XU3778 n2844 n1726 n1695 n3289 n2793 VDD VSS OAI22D4
XU3779 n2796 n2819 VDD VSS CKND2
XU3780 n2819 n2797 n2799 VDD VSS CKND2D1
XU3783 n1971 n2816 n2815 n2817 VDD VSS AOI21D2
XU3784 n2835 n1717 n2828 VDD VSS NR2XD1
XU3786 n180 n2850 n2834 VDD VSS NR2D3
XU3787 FE_OFN2738_x_10 n2854 n45 n2855 VDD VSS MUX2D1
XU3788 n183 n1688 n3096 VDD VSS NR2XD1
XU3790 n1633 n1708 n2905 VDD VSS ND2D2
XU3792 n2990 n2915 VDD VSS INVD1
XU3793 n2993 n2922 VDD VSS CKND2
XU3794 n2988 n2924 VDD VSS INVD0
XU3795 n2993 n904 n2929 VDD VSS CKND2D0
XU3798 n2951 n2969 n2953 VDD VSS CKND2D2
XU3799 csa_sum_1[27] csa_carry_1[27] n2977 VDD VSS ND2D2
XU3800 n2976 n2970 n2977 n2950 VDD VSS OAI21D1
XU3803 n2969 n2972 n2975 VDD VSS ND2D1
XU3805 n2976 n2978 VDD VSS INVD1
XU3806 x_mantissa[12] n2417 n2989 VDD VSS CKND2D0
XU3807 n3005 n2997 VDD VSS INVD0
XU3808 n3013 n3001 VDD VSS INVD0
XU3809 n3139 n3009 VDD VSS INVD0
XU3810 n3012 n3011 n3152 VDD VSS NR2D3
XU3811 n3332 n3017 VDD VSS INVD1
XU3812 n3019 n3139 n3141 n3020 VDD VSS OAI21D0
XU3813 FE_OFN77_n3022 n3021 n3020 n3023 VDD VSS AOI21D2
XU3814 n3138 n3025 VDD VSS INVD0
XU3815 FE_OFN59_n180 x_mantissa[16] n3142 VDD VSS CKND2D1
XU3816 n292 n3029 n3032 VDD VSS ND2D1
XU3817 FE_OFN78_n3030 n3029 n3028 n3031 VDD VSS AOI21D2
XU3818 n3164 n3333 n3035 VDD VSS CKND2D0
XU3819 n3203 n3337 n3046 VDD VSS CKND2D1
XU3821 n1572 n1864 n3076 VDD VSS NR2D0
XU3822 n3086 n1956 n3089 VDD VSS CKND2D0
XU3823 n3437 n254 n3085 VDD VSS NR2D0
XU3824 n72 n3085 n3088 VDD VSS ND2D2
XU3826 FE_OFN2800_n3084 n3085 n508 n3437 n3087 VDD VSS AOI22D1
XU3827 n3089 n174 n3088 n3087 n3125 VDD VSS OAI211D2
XU3828 n3099 n3096 n3095 n3101 VDD VSS IOA21D1
XU3829 n3104 n2575 n174 n3105 VDD VSS MUX2ND0
XU3830 FE_OFN102_n3172 FE_OFN2754_x_18 n3111 VDD VSS ND2D1
XU3831 n2504 n3233 n3870 n3117 VDD VSS MUX2ND2
XU3832 n3122 n3121 n3124 VDD VSS CKXOR2D1
XU3833 n3124 n3785 n3123 FE_OFN2802_x_22 n3579 VDD VSS OAI22D2
XU3834 n3579 n3578 n3698 VDD VSS CKND2D1
XU3835 n1566 n3131 n3130 n3127 n3711 VDD VSS FA1D2
XU3836 n3565 n3136 n3137 VDD VSS CKXOR2D1
XU3837 n3145 n3144 n3143 n3146 VDD VSS AOI21D1
XU3838 n3153 n3159 n3161 VDD VSS NR2XD1
XU3839 n1946 n3157 n3156 n3158 VDD VSS AOI21D2
XU3840 n3171 n3167 VDD VSS INVD0
XU3841 n3179 n3169 VDD VSS INVD0
XU3842 n1687 n2487 n3181 VDD VSS CKND2D1
XU3844 n3400 n3188 VDD VSS INVD1
XU3846 n3238 n1635 n3412 VDD VSS CKND2D1
XU3847 n3402 n3188 n3190 VDD VSS CKND2D0
XU3848 n3403 n3187 VDD VSS INVD0
XU3849 n3406 n3188 n3187 n3189 VDD VSS AOI21D0
XU3850 n2045 n3190 n3189 n3194 VDD VSS OAI21D2
XU3852 n3194 n3193 n3208 VDD VSS XNR2D4
XU3853 n3412 n3195 VDD VSS INVD0
XU3854 n1730 n1635 n3410 VDD VSS NR2XD1
XU3856 n1730 n1635 n3413 VDD VSS CKND2D0
XU3857 n3200 n3413 n3201 VDD VSS CKND2D0
XU3858 n3646 n3644 n3221 VDD VSS CKND2D2
XU3859 n3608 n3225 n3226 VDD VSS NR2D2
XU3860 n3227 FE_OCPN1587_n3228 n3229 VDD VSS CKND2D1
XU3861 n1642 n1688 n57 n3267 VDD VSS NR3D0
XU3862 FE_OCPN3463_n87 n1518 n3241 VDD VSS CKND2D2
XU3863 n3254 n3277 n3255 VDD VSS XNR2D4
XU3864 n3259 n3257 VDD VSS INVD0
XU3865 n3263 n1564 n3287 n3264 VDD VSS IOA21D2
XU3866 n3467 n3286 n3264 n3280 VDD VSS IOA21D2
XU3867 n3271 n2711 n3272 VDD VSS XNR2D1
XU3868 n3277 n3276 n3278 VDD VSS INR2D1
XU3869 n3467 n3281 n3280 n3296 n3298 VDD VSS FA1D4
XU3870 n3287 n3294 VDD VSS INVD1
XU3871 n3288 n3290 VDD VSS INVD0
XU3872 n2446 n3290 n325 n3293 VDD VSS MUX2ND2
XU3873 n3300 n3302 n3301 VDD VSS CKXOR2D1
XU3874 n3302 n3301 n3256 n3310 VDD VSS MUX2ND2
XU3875 n1643 n2825 n3303 VDD VSS INR2XD1
XU3876 n3304 n3303 n3306 VDD VSS CKXOR2D1
XU3877 n3310 n3556 VDD VSS INVD0
XU3878 n3455 n3318 VDD VSS INVD2
XU3879 n3356 n3358 VDD VSS INVD1
XU3880 n3358 FE_OCPN1173_n3357 n3359 VDD VSS ND2D2
XU3881 n2364 n3370 n3371 VDD VSS CKND2D1
XU3884 n3391 n3596 VDD VSS INVD1
XU3885 n3595 n3392 VDD VSS INVD1
XU3886 FE_OCPN1595_n3393 n3395 VDD VSS INVD1
XU3888 n3401 n3400 n3407 VDD VSS NR2D1
XU3889 n3407 n3406 n3405 n3789 VDD VSS AOI21D2
XU3890 n3416 n3415 n3414 n3795 VDD VSS AOI21D2
XU3891 n1577 n293 n3766 VDD VSS NR2D1
XU3892 n3506 n3503 n3420 n3421 VDD VSS AOI21D2
XU3893 n3768 n3423 VDD VSS INVD0
XU3894 n3760 n3432 VDD VSS INVD0
XU3895 n3789 n3764 VDD VSS INVD1
XU3896 n3761 n3433 VDD VSS INVD0
XU3897 n3764 n3434 n3433 n3435 VDD VSS AOI21D0
XU3898 n3758 n3439 VDD VSS INVD0
XU3899 n3441 n3440 n3448 VDD VSS XNR2D2
XU3902 n3487 n3486 shared_plane[11] VDD VSS XNR2D4
XU3903 FE_OCPN1197_n3489 n3491 VDD VSS INVD1
XU3904 n3491 FE_OCPN1188_n3490 n3492 VDD VSS ND2D2
XU3905 n3495 n3496 shared_plane[7] VDD VSS XNR2D4
XU3906 n3499 FE_RN_24 shared_plane[3] VDD VSS XNR2D2
XU3907 n1901 n3512 n3513 VDD VSS ND2D1
XU3908 n3536 n3535 n3539 VDD VSS CKXOR2D2
XU3909 n3565 n3564 n3566 VDD VSS CKXOR2D1
XU3910 n3567 n3569 VDD VSS INVD4
XU3911 n3599 n3571 VDD VSS INVD2
XU3912 n3571 n1666 n3573 VDD VSS NR2D2
XU3913 n244 n1666 FE_OCPN1201_n3600 n3572 VDD VSS OAI21D2
XU3914 n3574 n3576 VDD VSS INVD0
XU3915 n3576 n3575 n3577 VDD VSS ND2D1
XU3916 n3699 n3580 VDD VSS INVD1
XU3917 n3585 n3605 VDD VSS INVD2
XU3918 n3604 n3586 VDD VSS INVD1
XU3919 n3587 n3589 VDD VSS INVD1
XU3920 n3591 n3593 VDD VSS INVD1
XU3921 n3608 n3611 VDD VSS INVD2
XU3922 n3609 n3610 VDD VSS INVD2
XU3923 n3613 n3612 n3614 VDD VSS CKND2D1
XU3924 n3621 n3623 VDD VSS INVD0
XU3925 n3623 FE_OCPN1580_n3622 n3624 VDD VSS ND2D1
XU3927 n3631 n3633 VDD VSS INVD2
XU3928 n3644 n3645 VDD VSS INVD1
XU3929 FE_RN_143 selected_delta_3[25] VDD VSS CKND4
XU3930 n3674 n3676 VDD VSS INVD1
XU3931 n3679 n2357 n3681 VDD VSS XNR2D1
XU3932 n3685 selected_delta_2[26] VDD VSS INVD1
XU3933 FE_OCPN1198_n3690 n3692 VDD VSS INVD1
XU3934 n3692 n3691 n3693 VDD VSS CKND2D2
XU3935 n3707 n3706 n3709 VDD VSS XOR2D0
XU3936 n3711 n3710 n3712 VDD VSS XNR2D1
XU3937 n243 n3723 VDD VSS INVD0
XU3938 n3721 n3718 n3722 VDD VSS CKND2D0
XU3939 n3727 n3728 n3732 VDD VSS XNR2D1
XU3940 n3736 n3737 VDD VSS INVD2
XU3942 n3754 n3753 n3755 VDD VSS ND2D1
XU3943 n3764 n3763 n3786 n3765 VDD VSS AOI21D1
XU3944 n3767 n3766 n3772 VDD VSS NR2D1
XU3945 n3773 n3772 n3792 n3774 VDD VSS AOI21D1
XU3946 n3786 n322 n3787 VDD VSS NR2D0
XU3947 n3827 n3825 n3798 VDD VSS XNR2D1
XU3948 n3824 n3814 n3815 1000 VDD VSS HA1D0
XU3949 n3819 n3820 VDD VSS INVD0
XU3950 n3821 n2350 n3820 n3822 VDD VSS AOI21D2
XU3951 n3814 n3827 n3807 n3828 VDD VSS HA1D0
XU3952 n3828 n3829 VDD VSS INVD0
XU3953 shared_plane[8] divided_plane[8] n3835 mantissa_value[8] VDD VSS MUX2D4
.ENDS

.SUBCKT oadm_dm x[31] x[30] x[29] x[28] x[27] x[26] x[25] x[24] x[23] x[22]
+ x[21] x[20] x[19] x[18] x[17] x[16] x[15] x[14] x[13] x[12] x[11] x[10] x[9]
+ x[8] x[7] x[6] x[5] x[4] x[3] x[2] x[1] x[0] y[31] y[30] y[29] y[28] y[27]
+ y[26] y[25] y[24] y[23] y[22] y[21] y[20] y[19] y[18] y[17] y[16] y[15] y[14]
+ y[13] y[12] y[11] y[10] y[9] y[8] y[7] y[6] y[5] y[4] y[3] y[2] y[1] y[0]
+ level[1] level[0] divide_mode result[31] result[30] result[29] result[28]
+ result[27] result[26] result[25] result[24] result[23] result[22] result[21]
+ result[20] result[19] result[18] result[17] result[16] result[15] result[14]
+ result[13] result[12] result[11] result[10] result[9] result[8] result[7]
+ result[6] result[5] result[4] result[3] result[2] result[1] result[0] VDD VSS
XFE_PSC1656_n323 n323 FE_PSN1656_n323 VDD VSS BUFFD2
XFE_PSC1645_n316 n316 FE_PSN1645_n316 VDD VSS BUFFD2
XFE_PSC1643_n653 n653 FE_PSN1643_n653 VDD VSS CKBD0
XFE_PSC1642_n333 n333 FE_PSN1642_n333 VDD VSS CKBD1
XFE_PSBC1382_core_value_22 core_value[22] FE_PSBN3521_core_value_22 VDD VSS
+ CKBD4
XFE_PSC1633_core_value_23 core_value[23] FE_PSN1633_core_value_23 VDD VSS CKBD4
XFE_PSC1631_n287 n287 FE_PSN1631_n287 VDD VSS BUFFD2
XFE_PSC1629_n601 n601 FE_PSN1629_n601 VDD VSS BUFFD2
XFE_PSBC1381_core_value_26 core_value[26] FE_PSBN3520_core_value_26 VDD VSS
+ BUFFD4
XFE_PSC1615_n531 n531 FE_PSN1615_n531 VDD VSS BUFFD2
XFE_PSC1614_FE_RN_13 FE_RN_13 FE_PSN1614_FE_RN_13 VDD VSS BUFFD4
XFE_PSC1613_n667 n667 FE_PSN1613_n667 VDD VSS BUFFD4
XFE_OCPC1562_n529 n529 FE_OCPN1562_n529 VDD VSS BUFFD2
XFE_OCPC1552_core_value_20 core_value[20] FE_OCPN1552_core_value_20 VDD VSS
+ BUFFD2
XFE_RC_1746_0 n596 n221 n234 n613 FE_RN_967_0 VDD VSS OA22D4
XFE_RC_1745_0 n321 core_value[16] FE_RN_968_0 VDD VSS ND2D1
XFE_RC_1744_0 n314 n600 n247 n595 FE_RN_969_0 VDD VSS OAI22D2
XFE_RC_1743_0 FE_RN_969_0 FE_RN_968_0 FE_RN_967_0 FE_RN_970_0 VDD VSS IND3D4
XFE_RC_1742_0 FE_RN_970_0 FE_OCPN1136_n286 result[16] VDD VSS INR2XD2
XFE_OCPC1518_core_value_13 core_value[13] FE_OCPN1518_core_value_13 VDD VSS
+ CKBD1
XFE_OCPC1499_FE_OFN19_x_8 FE_OCPN1169_FE_OFN19_x_8 FE_OCPN1499_FE_OFN19_x_8 VDD
+ VSS CKBD0
XFE_OCPC1498_n205 n205 FE_OCPN1498_n205 VDD VSS BUFFD2
XFE_OCPC1474_n339 n339 FE_OCPN1474_n339 VDD VSS CKBD1
XFE_OCPC1455_n204 n204 FE_OCPN1455_n204 VDD VSS CKBD0
XFE_OCPC1419_FE_OFN1121_divide_mode FE_OFN1121_divide_mode
+ FE_OCPN1419_FE_OFN1121_divide_mode VDD VSS CKBD0
XFE_RC_1619_0 FE_RN_296_0 FE_RN_892_0 VDD VSS CKND2
XFE_RC_1618_0 FE_RN_297_0 n602 FE_RN_892_0 n604 VDD VSS INR3D2
XFE_RC_1594_0 n540 n561 VDD VSS CKND4
XFE_RC_1593_0 n540 n578 VDD VSS INVD4
XFE_OCPC1352_FE_OFN21_x_6 FE_OCPN3513_FE_OFN21_x_6 FE_OCPN3514_FE_OFN21_x_6 VDD
+ VSS INVD8
XFE_OCPC1351_FE_OFN21_x_6 FE_OFN21_x_6 FE_OCPN3513_FE_OFN21_x_6 VDD VSS INVD6
XFE_RC_1414_0 FE_OFN1356_n198 n248 n344 n348 VDD VSS ND3D8
XFE_RC_1408_0 n423 n424 FE_RN_778_0 VDD VSS NR2XD1
XFE_RC_1407_0 n335 FE_RN_778_0 n227 VDD VSS NR2XD3
XFE_OCPC1330_n239 FE_OCPN3511_n239 FE_OCPN3512_n239 VDD VSS CKND1
XFE_OCPC1328_n239 n239 FE_OCPN3511_n239 VDD VSS INVD8
XFE_OCPC1322_y_2 FE_OCPN3506_y_2 FE_OCPN3507_y_2 VDD VSS CKND2
XFE_OCPC1318_y_2 n668 FE_OCPN3506_y_2 VDD VSS CKND8
XFE_OCPC1316_y_2 y[2] n668 VDD VSS CKBD4
XFE_OCPC1311_x_4 FE_OFN23_x_4 FE_OFN1127_x_4 VDD VSS INVD6
XFE_OCPC1310_x_4 x[4] FE_OFN23_x_4 VDD VSS BUFFD6
XFE_RC_1377_0 n350 n155 n351 n165 n355 VDD VSS AOI22D4
XFE_OCPC1294_n422 n422 FE_RN_11 VDD VSS INVD4
XFE_OCPC1293_core_value_22 FE_OCPN1159_n332 FE_OCPN1314_n332 VDD VSS CKND1
XFE_OCPC1291_core_value_22 FE_PSBN3521_core_value_22 FE_OCPN1159_n332 VDD VSS
+ CKND1
XFE_OCPC1289_y_0 n666 FE_OCPN3504_y_0 VDD VSS INVD4
XFE_OCPC1288_y_0 y[0] n666 VDD VSS CKND2
XFE_OCPC1286_n198 FE_OCPN1140_n229 FE_RN_14 VDD VSS CKND6
XFE_OCPC1285_n198 FE_OCPN1140_n229 FE_OFN1356_n198 VDD VSS CKND12
XFE_OCPC1284_n198 n198 FE_OFN60_n198 VDD VSS BUFFD8
XFE_OCPC1283_n198 n198 FE_OCPN1140_n229 VDD VSS BUFFD8
XFE_RC_1357_0 FE_PSN1614_FE_RN_13 n338 n339 VDD VSS CKND2D8
XU221_dup n207 n206 FE_RN_17 VDD VSS CKND2D8
XU241_dup n413 FE_RN_16 VDD VSS INVD4
XFE_OFC58_n165_dup1 n165 FE_RN_15 VDD VSS BUFFD8
XFE_RC_1355_0 FE_OFN1356_n198 n248 n406 n410 VDD VSS ND3D8
XU480_dup core_value[27] core_value[26] FE_RN_13 VDD VSS NR2XD4
XU590_dup n415 n412 n413 n414 FE_RN_12 VDD VSS ND4D4
XFE_OCPC1387_n427 n427 FE_OCPN1387_n427 VDD VSS BUFFD4
XFE_OCPC1282_n287 n287 FE_OCPN3503_n287 VDD VSS CKBD4
XFE_OFC1358_n287 n287 FE_OFN1358_n287 VDD VSS BUFFD4
XU406_dup n259 FE_RN_2 VDD VSS CKND2
XFE_RC_1351_0 n534 FE_RN_747_0 VDD VSS CKND2
XFE_RC_1350_0 FE_RN_747_0 FE_RN_131_0 FE_RN_212_0 VDD VSS CKND2D2
XFE_RC_1349_0 n644 n250 FE_RN_746_0 VDD VSS ND2D2
XFE_RC_1348_0 n260 FE_RN_746_0 result[24] VDD VSS ND2D4
XFE_RC_1347_0 FE_OCPN1310_n158 n457 n337 n328 VDD VSS OAI21D4
XFE_RC_1333_0 FE_RN_373_0 n607 n606 n608 VDD VSS INR3D4
XFE_OCPC1250_FE_OFN1124_y_4 FE_OFN1124_y_4 FE_OCPN3447_y_4 VDD VSS CKND6
XFE_OCPC1249_n667 FE_PSN1613_n667 FE_OFN2722_y_1 VDD VSS INVD6
XFE_RC_1296_0 n317 n619 n290 n618 n626 VDD VSS OAI22D4
XFE_OCPC1330_core_value_27 core_value[27] FE_OCPN1330_core_value_27 VDD VSS
+ BUFFD4
XFE_RC_1286_0 n422 FE_OFN3416_n420 n367 n645 n426 VDD VSS IND4D4
XFE_RC_1249_0 n321 core_value[0] n188 core_value[1] n532 VDD VSS AOI22D4
XFE_OCPC1215_y_3 y[3] n239 VDD VSS BUFFD4
XFE_RC_1234_0 n483 n484 n482 n658 n512 VDD VSS OAI31D4
XFE_OCPC1213_core_value_11 core_value[11] FE_OCPN3464_core_value_11 VDD VSS
+ CKBD1
XFE_RC_1191_0 n319 core_value[9] FE_RN_667_0 VDD VSS ND2D2
XFE_RC_1190_0 FE_RN_667_0 n566 n567 n568 VDD VSS INR3D2
XFE_RC_1184_0 n315 n623 n596 FE_OFN3403_n242 n482 VDD VSS OAI22D4
XFE_RC_1176_0 n584 FE_RN_370_0 FE_RN_658_0 VDD VSS IND2D2
XFE_RC_1175_0 n585 FE_RN_658_0 n586 VDD VSS NR2D3
XFE_OCPC1321_FE_RN_303_0 FE_RN_303_0 FE_OCPN1321_FE_RN_303_0 VDD VSS BUFFD4
XFE_RC_1113_0 n190 FE_OFN1356_n198 n395 n399 VDD VSS ND3D8
XFE_RC_1099_0 core_value[12] core_value[11] core_value[10] n464 n465 VDD VSS
+ NR4D1
XFE_RC_1016_0 n322 core_value[3] n541 n542 n543 VDD VSS AOI211D2
XFE_OCPC1202_x_5 x[5] FE_OFN22_x_5 VDD VSS BUFFD6
XFE_RC_859_0 n400 n399 n398 n413 VDD VSS ND3D8
XFE_RC_824_0 n378 n377 n376 n415 VDD VSS ND3D8
XFE_OCPC1312_core_value_23 FE_PSN1633_core_value_23 FE_OCPN1312_core_value_23
+ VDD VSS CKBD4
XFE_OCPC1310_n158 n158 FE_OCPN1310_n158 VDD VSS BUFFD4
XFE_RC_807_0 n286 n612 result[19] VDD VSS NR2XD1
XFE_OCPC1307_n668 FE_OCPN3507_y_2 FE_OCPN1307_n668 VDD VSS CKBD0
XFE_RC_789_0 n339 n167 VDD VSS CKND6
XFE_RC_788_0 FE_OCPN1474_n339 FE_OCPN1149_core_value_23 n216 VDD VSS IND2D4
XFE_RC_787_0 n339 FE_OCPN1149_core_value_23 FE_OFN61_n216 VDD VSS IND2D4
XFE_RC_747_0 n411 n409 n410 n412 VDD VSS ND3D8
XFE_OCPC1199_x_0 x[0] FE_OFN1126_x_0 VDD VSS BUFFD6
XFE_RC_723_0 n268 n429 FE_RN_402_0 VDD VSS INR2XD0
XFE_RC_722_0 n630 FE_RN_402_0 n264 n440 VDD VSS ND3D4
XFE_RC_713_0 FE_RN_327_0 FE_RN_397_0 VDD VSS INVD1
XFE_RC_712_0 FE_RN_14 n248 FE_RN_397_0 n387 VDD VSS ND3D8
XFE_OCPC1193_FE_RN_8 n157 FE_OCPN3453_FE_RN_8 VDD VSS INVD8
XFE_OCPC1192_FE_RN_8 n157 FE_OCPN3452_FE_RN_8 VDD VSS INVD6
XFE_OCPC1191_FE_RN_8 n157 FE_OCPN3451_FE_RN_8 VDD VSS INVD8
XFE_OCPC1190_FE_RN_8 n157 n155 VDD VSS INVD12
XFE_OCPC1189_FE_RN_8 FE_RN_8 n157 VDD VSS CKND16
XFE_OFC58_n165_dup n165 FE_RN_9 VDD VSS BUFFD12
XFE_RC_669_0 n231 core_value[18] FE_RN_373_0 VDD VSS CKND2D4
XFE_OCPC1300_n666 FE_OCPN3504_y_0 FE_OCPN1300_n666 VDD VSS CKBD0
XFE_RC_663_0 n232 FE_OCPN1518_core_value_13 FE_RN_370_0 VDD VSS ND2D2
XFE_RC_660_0 n286 n576 result[11] VDD VSS NR2XD1
XFE_OCPC1177_n158 n158 FE_RN_303_0 VDD VSS CKND8
XFE_OCPC1176_n158 n158 FE_OCPN3435_n158 VDD VSS CKND6
XFE_OCPC1175_n158 n158 n164 VDD VSS CKND12
XFE_RC_656_0 n333 FE_RN_367_0 VDD VSS CKND2
XFE_RC_655_0 FE_RN_367_0 n219 FE_RN_368_0 VDD VSS IND2D4
XFE_RC_654_0 FE_RN_368_0 n440 n530 VDD VSS CKND2D4
XU471_dup FE_RN_12 n423 n335 FE_RN_10 VDD VSS IAO21D2
XFE_RC_592_0 n386 FE_RN_327_0 VDD VSS CKND1
XFE_RC_587_0 n530 n512 n513 n525 result[22] VDD VSS OAI31D4
XFE_RC_586_0 FE_RN_4 FE_RN_12 FE_RN_326_0 VDD VSS NR2XD4
XFE_RC_585_0 FE_RN_1 FE_RN_326_0 n427 VDD VSS NR2D8
XFE_OCPC1295_n649 n649 FE_OCPN1295_n649 VDD VSS CKBD1
XFE_OCPC1283_FE_OFN2722_y_1 FE_OFN2722_y_1 FE_OCPN1283_FE_OFN2722_y_1 VDD VSS
+ CKBD0
XU254_dup FE_RN_13 n338 FE_RN_8 VDD VSS CKND2D8
XFE_OCPC1158_x_3 FE_OFN24_x_3 FE_OCPN3448_x_3 VDD VSS INVD4
XFE_OCPC1156_x_3 x[3] FE_OFN24_x_3 VDD VSS CKND2
XFE_RC_551_0 n164 n312 n419 VDD VSS ND2D4
XFE_OCPC1150_y_4 y[4] FE_OFN1124_y_4 VDD VSS CKND3
XFE_RC_550_0 FE_OCPN3503_n287 n586 result[13] VDD VSS NR2D4
XFE_RC_543_0 n603 FE_RN_296_0 VDD VSS INVD2
XFE_RC_542_0 n322 core_value[17] FE_RN_297_0 VDD VSS ND2D2
XFE_OCPC1239_n165 n165 FE_OCPN1239_n165 VDD VSS BUFFD4
XFE_RC_522_0 FE_OFN1358_n287 n559 result[7] VDD VSS NR2D2
XFE_RC_486_0 n359 n432 n165 n360 n366 VDD VSS AOI22D4
XFE_RC_482_0 FE_RN_177_0 n468 n614 n469 VDD VSS NR3D3
XU249_dup n653 n655 FE_RN_16 n649 FE_RN_7 VDD VSS ND4D4
XFE_RC_409_0 n365 n366 n364 n421 VDD VSS ND3D8
XFE_RC_404_0 n230 n221 n289 n600 n603 VDD VSS OAI22D2
XFE_RC_387_0 FE_RN_45_0 FE_RN_212_0 result[1] VDD VSS NR2XD2
XFE_OCPC1129_y_3 FE_OCPN3512_n239 FE_OCPN3437_y_3 VDD VSS CKND1
XFE_RC_334_0 core_value[20] core_value[19] FE_RN_177_0 VDD VSS OR2D4
XU246_dup FE_OFN3416_n420 FE_RN_11 n367 n645 FE_RN_6 VDD VSS ND4D4
XFE_RC_327_0 FE_RN_303_0 n436 n168 n438 n334 VDD VSS AOI22D4
XFE_RC_245_0 FE_RN_44_0 FE_RN_131_0 VDD VSS CKND1
XFE_OCPC1189_n631 n631 FE_OCPN1189_n631 VDD VSS CKBD0
XFE_OCPC1169_FE_OFN19_x_8 FE_OFN19_x_8 FE_OCPN1169_FE_OFN19_x_8 VDD VSS BUFFD8
XFE_OCPC1160_n420 n420 FE_OCPN1160_n420 VDD VSS CKBD0
XFE_OCPC1154_n531 n531 FE_OCPN1154_n531 VDD VSS BUFFD2
XFE_OCPC1149_core_value_23 FE_OCPN1312_core_value_23 FE_OCPN1149_core_value_23
+ VDD VSS BUFFD4
XFE_OCPC1147_n651 FE_RN_16 FE_OCPN1147_n651 VDD VSS CKBD1
XFE_RC_85_0 n531 FE_OFN63_n531 VDD VSS BUFFD8
XFE_RC_84_0 FE_PSN1615_n531 FE_RN_43_0 VDD VSS CKND2
XFE_RC_83_0 FE_RN_43_0 FE_RN_10 n629 VDD VSS IND2D4
XFE_RC_82_0 n531 FE_RN_44_0 VDD VSS INVD1
XFE_RC_81_0 FE_RN_10 FE_RN_45_0 VDD VSS CKND2
XFE_OCPC1138_n339 n339 FE_OCPN1138_n339 VDD VSS BUFFD2
XFE_RC_74_0 n389 n387 n388 n414 VDD VSS ND3D8
XFE_OCPC1136_n286 n286 FE_OCPN1136_n286 VDD VSS BUFFD4
XU256_dup n422 n420 n631 n421 FE_RN_4 VDD VSS ND4D4
XFE_RC_61_0 n349 n347 n348 n422 VDD VSS ND3D8
XU491_dup core_value[22] core_value[24] FE_RN_3 VDD VSS NR2D8
XU470_dup n425 n426 FE_RN_1 VDD VSS NR2XD4
XFE_RC_33_0 n164 n343 n155 n342 n349 VDD VSS AOI22D4
XFE_RC_29_0 n215 n194 FE_RN_17_0 VDD VSS ND2D4
XFE_RC_28_0 FE_RN_17_0 FE_RN_16_0 VDD VSS INVD4
XFE_RC_27_0 FE_RN_16_0 core_value[21] n204 n158 VDD VSS ND3D8
XFE_OFC1135_x_14 x[14] FE_OFN1135_x_14 VDD VSS BUFFD2
XFE_OFC1134_x_10 x[10] FE_OFN1134_x_10 VDD VSS BUFFD2
XFE_OFC1133_x_19 x[19] FE_OFN1133_x_19 VDD VSS BUFFD2
XFE_OFC1132_x_21 x[21] FE_OFN1132_x_21 VDD VSS BUFFD4
XFE_OFC1131_y_20 y[20] FE_OFN1131_y_20 VDD VSS CKBD1
XFE_OFC1130_y_9 y[9] FE_OFN1130_y_9 VDD VSS BUFFD2
XFE_OFC1129_x_13 x[13] FE_OFN1129_x_13 VDD VSS BUFFD2
XFE_OFC1128_x_7 x[7] FE_OFN1128_x_7 VDD VSS BUFFD4
XFE_OFC1125_y_5 y[5] FE_OFN1125_y_5 VDD VSS CKBD4
XFE_OFC1123_y_25 y[25] FE_OFN3434_y_25 VDD VSS CKBD0
XFE_OFC1122_y_24 y[24] FE_OFN3433_y_24 VDD VSS CKBD0
XFE_OFC1121_y_23 y[23] FE_OFN3432_y_23 VDD VSS CKBD0
XFE_OFC1123_level_1 level[1] FE_OFN1123_level_1 VDD VSS BUFFD2
XFE_OFC1122_level_0 level[0] FE_OFN1122_level_0 VDD VSS BUFFD2
XFE_OFC1121_divide_mode divide_mode FE_OFN1121_divide_mode VDD VSS BUFFD8
XFE_OFC1078_n340 FE_OCPN1149_core_value_23 n452 VDD VSS CKND1
XFE_OFC1055_n420 n420 FE_OFN3416_n420 VDD VSS INVD6
XFE_OFC1054_n420 FE_OCPN1160_n420 n643 VDD VSS CKND1
XFE_OFC997_y_17 y[17] n670 VDD VSS CKBD4
XFE_OFC968_y_17 n670 FE_OFN3408_y_17 VDD VSS CKND0
XFE_OFC963_core_value_16 core_value[16] n609 VDD VSS CKND1
XFE_OFC962_core_value_16 core_value[16] n467 VDD VSS CKND2
XFE_OFC961_core_value_17 core_value[17] n613 VDD VSS CKND1
XFE_OFC960_core_value_17 core_value[17] n201 VDD VSS INVD4
XFE_OFC922_y_7 FE_OFN3406_n FE_OFN3407_n VDD VSS CKND0
XFE_OFC921_y_7 FE_OFN50_y_7 FE_OFN3406_n VDD VSS INVD8
XFE_OFC877_n242 n614 FE_OFN3403_n242 VDD VSS CKND1
XFE_OFC876_n242 n242 n614 VDD VSS CKND2
XFE_OFC862_x_13 n302 n301 VDD VSS CKND1
XFE_OFC861_x_13 FE_OFN1129_x_13 n302 VDD VSS CKND4
XFE_OFC860_n451 n188 n325 VDD VSS CKND2
XFE_OFC859_n451 n188 n326 VDD VSS INVD4
XFE_OFC858_n451 n233 n324 VDD VSS CKND2
XFE_OFC857_n451 n233 n323 VDD VSS CKND6
XFE_OFC856_n451 n233 n234 VDD VSS CKND2
XFE_OFC855_n451 n233 n622 VDD VSS INVD2
XFE_OFC854_n451 n451 n188 VDD VSS INVD4
XFE_OFC853_n451 n451 n233 VDD VSS CKND4
XFE_OFC838_n220 n220 n317 VDD VSS INVD4
XFE_OFC837_n220 n220 n316 VDD VSS INVD4
XFE_OFC836_n220 n220 n230 VDD VSS INVD4
XFE_OFC835_n220 n220 n315 VDD VSS INVD4
XFE_OFC791_x_7 FE_OFN1128_x_7 FE_OFN20_x_7 VDD VSS CKND12
XFE_OFC770_y_13 n306 n305 VDD VSS CKND0
XFE_OFC769_y_13 y[13] n306 VDD VSS CKND2
XFE_OFC760_x_10 FE_OFN1134_x_10 n182 VDD VSS CKND6
XFE_OFC727_x_22 FE_OFN9_x_22 FE_OFN2801_x_22 VDD VSS CKND1
XFE_OFC726_x_22 x[22] FE_OFN9_x_22 VDD VSS INVD3
XFE_OFC716_x_18 x[18] n671 VDD VSS BUFFD4
XFE_OFC669_y_16 y[16] FE_OFN41_y_16 VDD VSS BUFFD4
XFE_OFC658_y_19 y[19] FE_OFN39_y_19 VDD VSS CKBD4
XFE_OFC651_x_6 FE_OCPN3514_FE_OFN21_x_6 FE_OFN2793_x_6 VDD VSS CKND0
XFE_OFC648_x_6 x[6] FE_OFN21_x_6 VDD VSS CKND2
XFE_OFC611_x_7 FE_OFN20_x_7 FE_OFN2784_x_7 VDD VSS CKND0
XFE_OFC601_y_8 FE_OFN49_y_8 FE_OFN2783_y_8 VDD VSS CKND0
XFE_OFC600_y_8 y[8] FE_OFN49_y_8 VDD VSS CKND2
XFE_OFC596_y_12 y[12] FE_OFN45_y_12 VDD VSS BUFFD4
XFE_OFC547_y_21 y[21] FE_OFN37_y_21 VDD VSS CKND2
XFE_OFC539_y_10 y[10] n300 VDD VSS INVD3
XFE_OFC533_y_9 n309 FE_OFN48_y_9 VDD VSS CKND0
XFE_OFC532_y_9 FE_OFN1130_y_9 n309 VDD VSS BUFFD12
XFE_OFC531_n339 n167 n169 VDD VSS CKND2
XFE_OFC530_n339 n167 n168 VDD VSS INVD4
XFE_OFC516_y_22 FE_OFN36_y_22 FE_OFN2779_y_22 VDD VSS CKND1
XFE_OFC515_y_22 y[22] FE_OFN36_y_22 VDD VSS CKND2
XFE_OFC504_y_3 FE_OCPN3437_y_3 FE_OFN2778_y_3 VDD VSS CKND0
XFE_OFC497_core_value_15 core_value[15] n221 VDD VSS CKND1
XFE_OFC496_core_value_15 core_value[15] n605 VDD VSS CKND2
XFE_OFC495_core_value_11 FE_OCPN3464_core_value_11 n587 VDD VSS CKND1
XFE_OFC494_core_value_20 FE_OCPN1552_core_value_20 n623 VDD VSS CKND1
XFE_OFC489_core_value_6 core_value[6] n565 VDD VSS CKND1
XFE_OFC476_core_value_8 core_value[8] n573 VDD VSS CKND1
XFE_OFC475_core_value_13 FE_OCPN1518_core_value_13 n595 VDD VSS CKND1
XFE_OFC474_core_value_12 core_value[12] n591 VDD VSS CKND1
XFE_OFC473_core_value_4 core_value[4] n556 VDD VSS CKND1
XFE_OFC472_core_value_10 core_value[10] n582 VDD VSS CKND1
XFE_OFC470_core_value_9 core_value[9] n577 VDD VSS CKND1
XFE_OFC469_core_value_9 core_value[9] n224 VDD VSS CKND2
XFE_OFC463_core_value_19 core_value[19] n619 VDD VSS CKND1
XFE_OFC430_core_value_5 n223 FE_OFN2763_core_value_5 VDD VSS CKND1
XFE_OFC429_core_value_5 n560 n223 VDD VSS CKND1
XFE_OFC428_core_value_5 core_value[5] n560 VDD VSS CKND4
XFE_OFC398_core_value_7 core_value[7] n569 VDD VSS CKND1
XFE_OFC366_x_21 FE_OFN10_x_21 FE_OFN2751_x_21 VDD VSS CKND1
XFE_OFC365_x_21 FE_OFN1132_x_21 FE_OFN10_x_21 VDD VSS INVD8
XFE_OFC345_core_value_0 core_value[0] n539 VDD VSS CKND1
XFE_OFC319_y_20 FE_OFN1131_y_20 FE_OFN38_y_20 VDD VSS BUFFD6
XFE_OFC309_x_11 x[11] n184 VDD VSS CKND3
XFE_OFC303_x_19 FE_OFN12_x_19 FE_OFN2740_x_19 VDD VSS CKND1
XFE_OFC302_x_19 FE_OFN1133_x_19 FE_OFN12_x_19 VDD VSS CKND6
XFE_OFC297_x_16 x[16] FE_OFN14_x_16 VDD VSS BUFFD4
XFE_OFC283_x_2 x[2] FE_OFN25_x_2 VDD VSS BUFFD6
XFE_OFC269_x_14 FE_OFN15_x_14 FE_OFN2737_x_14 VDD VSS CKND1
XFE_OFC268_x_14 FE_OFN1135_x_14 FE_OFN15_x_14 VDD VSS INVD4
XFE_OFC241_y_15 y[15] FE_OFN42_y_15 VDD VSS BUFFD6
XFE_OFC235_x_17 FE_OFN13_x_17 FE_OFN2736_x_17 VDD VSS CKND1
XFE_OFC234_x_17 x[17] FE_OFN13_x_17 VDD VSS CKND2
XFE_OFC232_x_15 n180 n179 VDD VSS CKND0
XFE_OFC229_x_15 x[15] n180 VDD VSS CKND3
XFE_OFC223_x_9 x[9] n308 VDD VSS BUFFD3
XFE_OFC215_x_12 x[12] FE_OFN16_x_12 VDD VSS BUFFD6
XFE_OFC200_y_10 n300 FE_OFN47_y_10 VDD VSS CKND1
XFE_OFC174_y_21 FE_OFN37_y_21 FE_OFN2730_y_21 VDD VSS CKND0
XFE_OFC170_core_value_21 core_value[21] n242 VDD VSS CKND1
XFE_OFC165_x_8 FE_OCPN1499_FE_OFN19_x_8 FE_OFN2729_x_8 VDD VSS CKND0
XFE_OFC164_x_8 x[8] FE_OFN19_x_8 VDD VSS CKND2
XFE_OFC158_y_6 y[6] FE_OFN51_y_6 VDD VSS BUFFD6
XFE_OFC123_x_4 FE_OFN1127_x_4 FE_OFN2723_x_4 VDD VSS CKND0
XFE_OFC118_y_1 y[1] n667 VDD VSS INVD2
XFE_OFC96_n286 n286 FE_OFN96_n286 VDD VSS BUFFD8
XFE_OFC50_y_7 y[7] FE_OFN50_y_7 VDD VSS BUFFD4
XFE_OFC46_y_11 y[11] FE_OFN46_y_11 VDD VSS BUFFD6
XFE_OFC44_y_14 y[14] FE_OFN44_y_14 VDD VSS BUFFD4
XFE_OFC40_y_18 y[18] FE_OFN40_y_18 VDD VSS BUFFD4
XFE_OFC35_y_23 FE_OFN3432_y_23 FE_OFN35_y_23 VDD VSS CKBD0
XFE_OFC34_y_24 FE_OFN3433_y_24 FE_OFN34_y_24 VDD VSS CKBD0
XFE_OFC33_y_25 FE_OFN3434_y_25 FE_OFN33_y_25 VDD VSS CKBD0
XFE_OFC32_y_26 y[26] FE_OFN32_y_26 VDD VSS CKBD0
XFE_OFC31_y_27 y[27] FE_OFN31_y_27 VDD VSS CKBD0
XFE_OFC30_y_28 y[28] FE_OFN30_y_28 VDD VSS CKBD0
XFE_OFC29_y_29 y[29] FE_OFN29_y_29 VDD VSS CKBD0
XFE_OFC28_y_30 y[30] FE_OFN28_y_30 VDD VSS CKBD0
XFE_OFC27_y_31 y[31] FE_OFN27_y_31 VDD VSS CKBD0
XFE_OFC11_x_20 x[20] FE_OFN11_x_20 VDD VSS BUFFD6
XFE_OFC8_x_23 x[23] FE_OFN8_x_23 VDD VSS CKBD0
XFE_OFC7_x_24 x[24] FE_OFN7_x_24 VDD VSS CKBD0
XFE_OFC6_x_25 x[25] FE_OFN6_x_25 VDD VSS CKBD0
XFE_OFC5_x_26 x[26] FE_OFN5_x_26 VDD VSS CKBD0
XFE_OFC4_x_27 x[27] FE_OFN4_x_27 VDD VSS CKBD0
XFE_OFC3_x_28 x[28] FE_OFN3_x_28 VDD VSS CKBD0
XFE_OFC2_x_29 x[29] FE_OFN2_x_29 VDD VSS CKBD0
XFE_OFC1_x_30 x[30] FE_OFN1_x_30 VDD VSS CKBD0
XFE_OFC0_x_31 x[31] FE_OFN0_x_31 VDD VSS CKBD0
Xmantissa_core VSS FE_OFN9_x_22 FE_OFN10_x_21 FE_OFN11_x_20 FE_OFN12_x_19 n671
+ FE_OFN13_x_17 FE_OFN14_x_16 n180 FE_OFN15_x_14 n302 FE_OFN16_x_12 n184 n182
+ n308 FE_OCPN1169_FE_OFN19_x_8 FE_OFN20_x_7 FE_OCPN3513_FE_OFN21_x_6
+ FE_OFN22_x_5 FE_OFN23_x_4 FE_OFN24_x_3 FE_OFN25_x_2 n304 FE_OFN1126_x_0 VSS
+ FE_OFN36_y_22 FE_OFN37_y_21 FE_OFN38_y_20 FE_OFN39_y_19 FE_OFN40_y_18 n670
+ FE_OFN41_y_16 FE_OFN42_y_15 FE_OFN44_y_14 n306 FE_OFN45_y_12 FE_OFN46_y_11
+ n300 n309 FE_OFN49_y_8 FE_OFN3406_n FE_OFN51_y_6 FE_OFN1125_y_5
+ FE_OCPN3447_y_4 n239 n668 FE_OFN2722_y_1 n666 FE_OFN1123_level_1
+ FE_OFN1122_level_0 FE_OFN1121_divide_mode core_value[28] core_value[27]
+ core_value[26] core_value[25] core_value[24] core_value[23] core_value[22]
+ core_value[21] core_value[20] core_value[19] core_value[18] core_value[17]
+ core_value[16] core_value[15] core_value[14] core_value[13] core_value[12]
+ core_value[11] core_value[10] core_value[9] core_value[8] core_value[7]
+ core_value[6] core_value[5] core_value[4] core_value[3] core_value[2]
+ core_value[1] core_value[0] VDD VSS n667 FE_OFN1124_y_4 FE_OCPN3448_x_3
+ FE_OCPN3504_y_0 FE_OFN1127_x_4 FE_OCPN3507_y_2 FE_OCPN3506_y_2
+ FE_OCPN3511_n239 FE_OCPN3514_FE_OFN21_x_6 oadm_core
XDP_OP_57J2_122_2635_U9 FE_OFN8_x_23 C2_Z_0 DP_OP_58J2_123_7635_n43
+ DP_OP_57J2_122_2635_n8 VDD VSS HA1D0
XDP_OP_57J2_122_2635_U8 FE_OFN7_x_24 C2_Z_1 DP_OP_57J2_122_2635_n8
+ DP_OP_58J2_123_7635_n44 DP_OP_57J2_122_2635_n7 VDD VSS FA1D0
XDP_OP_57J2_122_2635_U7 FE_OFN6_x_25 C2_Z_2 DP_OP_57J2_122_2635_n7
+ DP_OP_58J2_123_7635_n45 DP_OP_57J2_122_2635_n6 VDD VSS FA1D0
XDP_OP_57J2_122_2635_U6 FE_OFN5_x_26 C2_Z_3 DP_OP_57J2_122_2635_n6
+ DP_OP_58J2_123_7635_n46 DP_OP_57J2_122_2635_n5 VDD VSS FA1D0
XDP_OP_57J2_122_2635_U5 FE_OFN4_x_27 C2_Z_4 DP_OP_57J2_122_2635_n5
+ DP_OP_58J2_123_7635_n47 DP_OP_57J2_122_2635_n4 VDD VSS FA1D0
XDP_OP_57J2_122_2635_U4 FE_OFN3_x_28 C2_Z_5 DP_OP_57J2_122_2635_n4
+ DP_OP_58J2_123_7635_n48 DP_OP_57J2_122_2635_n3 VDD VSS FA1D0
XDP_OP_57J2_122_2635_U3 FE_OFN2_x_29 C2_Z_6 DP_OP_57J2_122_2635_n3
+ DP_OP_58J2_123_7635_n49 DP_OP_57J2_122_2635_n2 VDD VSS FA1D0
XDP_OP_57J2_122_2635_U2 FE_OFN1_x_30 C2_Z_7 DP_OP_57J2_122_2635_n2
+ DP_OP_58J2_123_7635_n50 DP_OP_57J2_122_2635_n1 VDD VSS FA1D0
XU192 n250 n648 n260 result[26] VDD VSS IOA21D2
XU193 n331 FE_RN_2 result[30] VDD VSS ND2D1
XU194 n529 n658 VDD VSS INVD1
XU195 n189 n246 VDD VSS INVD6
XU196 n189 n289 VDD VSS INVD3
XU197 n156 n247 VDD VSS CKND4
XU198 n620 n222 VDD VSS INVD2
XU200 n627 n228 VDD VSS CKND4
XU202 n245 FE_OFN61_n216 n627 VDD VSS INR2XD2
XU204 n450 n156 VDD VSS INVD4
XU206 FE_OCPN1321_FE_RN_303_0 n245 n454 VDD VSS CKND2D4
XU207 n167 n208 n333 VDD VSS ND2D2
XU208 n419 n416 n217 VDD VSS ND2D4
XU209 n166 n341 n417 VDD VSS CKND2D8
XU211 n197 n352 n353 VDD VSS ND2D4
XU212 FE_RN_303_0 n361 n365 VDD VSS CKND2D4
XU213 FE_RN_303_0 n283 n354 VDD VSS CKND2D4
XU214 FE_OCPN3435_n158 n382 FE_OCPN3451_FE_RN_8 n381 n389 VDD VSS AOI22D4
XU217 FE_RN_17 n190 VDD VSS CKND6
XU218 n358 FE_OFN60_n198 n359 VDD VSS INR2D4
XU221 n207 n206 n327 VDD VSS ND2D8
XU223 n402 n279 n403 n391 VDD VSS HA1D0
XU224 n369 n271 n342 n402 VDD VSS HA1D0
XU233 n313 n284 n351 VDD VSS XNR2D1
XU238 n336 FE_OCPN1138_n339 n480 n330 VDD VSS OAI21D2
XU239 n218 n217 n367 VDD VSS NR2D8
XU240 n412 n649 VDD VSS INVD6
XU241 n413 n651 VDD VSS INVD4
XU243 core_value[25] core_value[23] n194 VDD VSS NR2XD8
XU244 n418 n419 n417 n416 n631 VDD VSS ND4D4
XU247 FE_RN_3 n194 n198 VDD VSS ND2D4
XU249 n653 n649 n651 n655 n425 VDD VSS ND4D4
XU251 n390 n275 n393 VDD VSS XNR2D1
XU253 FE_OFN61_n216 n418 n417 n218 VDD VSS ND3D8
XU255 n285 n282 n361 VDD VSS XNR2D1
XU256 n422 n420 n631 n421 n423 VDD VSS ND4D4
XU257 n164 n404 FE_OCPN3452_FE_RN_8 n403 n411 VDD VSS AOI22D4
XU258 n414 n655 VDD VSS INVD6
XU261 n401 n278 n404 VDD VSS XNR2D1
XU262 n368 N65 n343 VDD VSS XNR2D1
XU263 n435 n264 n382 VDD VSS XNR2D1
XU264 n379 n268 n371 VDD VSS XNR2D1
XU268 n334 n216 n434 n219 VDD VSS ND3D4
XU272 core_value[25] core_value[24] n338 VDD VSS NR2XD8
XU273 FE_RN_17 n248 VDD VSS CKND12
XU274 FE_OCPN1330_core_value_27 n206 VDD VSS INVD6
XU275 n227 FE_OFN63_n531 n159 VDD VSS ND2D4
XU278 n578 n160 VDD VSS INVD4
XU279 n578 n161 VDD VSS INVD4
XU280 n203 n165 VDD VSS CKND12
XU281 n203 n166 VDD VSS INVD4
XU282 n204 n193 FE_PSBN3521_core_value_22 n203 VDD VSS ND3D8
XU283 n303 n304 VDD VSS INVD6
XU284 FE_PSBN3520_core_value_26 core_value[21] n207 VDD VSS NR2D8
XU287 FE_OCPN1283_FE_OFN2722_y_1 n172 VDD VSS INVD0
XU288 n172 n173 VDD VSS INVD0
XU289 n161 n556 n324 n565 n549 VDD VSS OAI22D2
XU290 n189 n174 VDD VSS INVD2
XU291 n450 n189 VDD VSS INVD6
XU293 FE_OFN16_x_12 n175 VDD VSS INVD0
XU294 n175 n176 VDD VSS INVD0
XU295 FE_OFN22_x_5 n177 VDD VSS INVD0
XU296 n177 n178 VDD VSS INVD0
XU299 n182 n183 VDD VSS INVD0
XU301 n184 n186 VDD VSS INVD0
XU302 n522 n517 C2_Z_1 VDD VSS CKND2D0
XU303 n522 n521 C2_Z_6 VDD VSS CKND2D0
XU308 n231 core_value[15] n593 n592 n594 VDD VSS AOI211D2
XU309 N69 n263 VDD VSS INVD0
XU310 n605 n466 n465 n187 VDD VSS AN3D2
XU311 N68 n266 VDD VSS INVD0
XU312 n266 n268 VDD VSS INVD0
XU313 N65 n269 VDD VSS INVD0
XU314 N64 n280 VDD VSS INVD0
XU316 N67 n274 VDD VSS INVD0
XU317 N63 n283 VDD VSS INVD0
XU318 N66 n277 VDD VSS INVD0
XU319 n277 n279 VDD VSS INVD0
XU320 n620 n314 VDD VSS INVD4
XU321 n488 n522 VDD VSS CKBD1
XU322 n254 n488 VDD VSS INVD0
XU323 n262 N68 FE_PSN1643_n653 n654 VDD VSS IOA21D1
XU324 n156 n290 VDD VSS INVD2
XU325 n630 n262 VDD VSS BUFFD2
XU326 n197 n638 n450 VDD VSS ND2D3
XU328 n456 n191 n457 VDD VSS OR2D0
XU329 n191 N69 n460 n336 VDD VSS OR3D0
XU330 n267 n385 n430 VDD VSS OR2D0
XU331 DP_OP_57J2_122_2635_n1 DP_OP_58J2_123_7635_n3 n634 VDD VSS XNR2D1
XU332 DP_OP_58J2_123_7635_n3 DP_OP_57J2_122_2635_n1 n337 VDD VSS OR2D0
XU333 n428 n279 n276 n429 VDD VSS IND3D0
XU334 n274 n275 VDD VSS INVD0
XU335 n274 n276 VDD VSS INVD0
XU336 n269 n271 VDD VSS INVD0
XU337 n280 n282 VDD VSS INVD0
XU338 n283 n284 VDD VSS INVD0
XU339 n639 n245 n640 VDD VSS IND2D0
XU340 n521 n515 n664 VDD VSS CKAN2D0
XU341 n524 n226 n665 VDD VSS CKND2D0
XU342 n520 n519 C2_Z_5 VDD VSS CKND2D1
XU343 n474 n449 n493 VDD VSS CKND2D0
XU345 n476 n475 n485 VDD VSS CKND2D0
XU346 FE_OFN33_y_25 n527 VDD VSS INVD0
XU347 FE_OFN32_y_26 n528 VDD VSS INVD0
XU348 n212 FE_OCPN1498_n205 n211 VDD VSS ND2D2
XU349 n319 core_value[8] n563 n562 n564 VDD VSS AOI211D2
XU350 n421 n645 VDD VSS INVD6
XU351 n630 n656 VDD VSS BUFFD2
XU353 N69 n430 n455 VDD VSS OR2D1
XU354 n275 n394 n385 VDD VSS OR2D0
XU355 n276 n390 n379 VDD VSS OR2D0
XU356 n266 n267 VDD VSS INVD0
XU357 n665 DP_OP_58J2_123_7635_n50 DP_OP_58J2_123_7635_n4 N69
+ DP_OP_58J2_123_7635_n3 VDD VSS FA1D0
XU358 n280 n281 VDD VSS INVD0
XU359 n283 n285 VDD VSS INVD0
XU360 n639 n511 n525 VDD VSS NR2D2
XU361 n633 n311 VDD VSS INVD0
XU362 DP_OP_58J2_123_7635_n43 n514 n633 VDD VSS XOR2D0
XU363 n519 n515 n663 VDD VSS CKAN2D0
XU364 n499 n498 n497 n639 VDD VSS IOA21D0
XU365 n518 n515 n662 VDD VSS CKAN2D0
XU366 n516 n515 n514 VDD VSS CKAN2D0
XU367 n507 n499 n638 VDD VSS INR2D1
XU368 n470 n445 n444 n443 n502 VDD VSS ND4D0
XU369 n442 n441 n507 VDD VSS CKND2D0
XU371 n447 n446 n474 VDD VSS NR2D0
XU372 FE_OFN35_y_23 n516 VDD VSS INVD0
XU373 n262 n281 n645 n646 VDD VSS IOA21D0
XU374 n641 FE_PSN1642_n333 n214 VDD VSS CKND2D2
XU375 n205 n641 n529 VDD VSS CKND2D8
XU376 n454 n620 VDD VSS INVD4
XU377 n197 n458 n196 VDD VSS ND2D2
XU378 n277 n278 VDD VSS INVD0
XU379 n638 n245 VDD VSS BUFFD1
XU380 n496 n495 n494 n497 VDD VSS OAI21D0
XU383 n222 n577 n246 n573 n575 VDD VSS OAI22D2
XU384 n222 n573 n174 n569 n571 VDD VSS OAI22D2
XU385 n530 n529 n531 VDD VSS NR2XD4
XU386 n316 n539 n536 VDD VSS NR2XD1
XU388 n214 n213 n212 VDD VSS NR2D1
XU389 n656 n275 FE_OCPN1147_n651 n652 VDD VSS IOA21D2
XU390 FE_OCPN1562_n529 n250 VDD VSS CKND2
XU391 n622 n452 n453 FE_OFN61_n216 n483 VDD VSS OAI22D2
XU392 n479 core_value[28] n480 VDD VSS NR2XD2
XU393 n200 core_value[18] n199 VDD VSS NR2XD1
XU394 n455 n191 n458 VDD VSS NR2D1
XU395 n634 n459 VDD VSS INVD1
XU396 n523 n524 C2_Z_7 VDD VSS NR2D1
XU397 n520 n518 C2_Z_4 VDD VSS CKND2D1
XU398 n520 n516 C2_Z_0 VDD VSS CKND2D1
XU399 n253 n528 C2_Z_3 VDD VSS CKND2D1
XU400 n488 n527 C2_Z_2 VDD VSS CKND2D1
XU404 n320 FE_OCPN3464_core_value_11 n575 n574 n576 VDD VSS AOI211D4
XU405 n259 n260 VDD VSS CKND4
XU406 n259 n261 VDD VSS CKND4
XU407 n321 core_value[10] n571 n570 n572 VDD VSS AOI211D2
XU408 n231 core_value[6] n554 n553 n555 VDD VSS AOI211D4
XU409 n211 n210 n259 VDD VSS ND2D4
XU410 n222 n556 n289 n552 n554 VDD VSS OAI22D2
XU412 n320 core_value[7] n558 n557 n559 VDD VSS AOI211D4
XU413 n232 core_value[12] n580 n579 n581 VDD VSS AOI211D2
XU415 n320 core_value[14] n589 n588 n590 VDD VSS AOI211D2
XU418 n232 FE_OCPN1552_core_value_20 n616 n615 n617 VDD VSS AOI211D4
XU419 n320 n223 n550 n549 n551 VDD VSS AOI211D4
XU420 n319 core_value[19] n611 n610 n612 VDD VSS AOI211D2
XU422 n249 n657 n331 VDD VSS ND2D2
XU424 n314 n613 n246 n609 n611 VDD VSS OAI22D2
XU425 n355 n354 n353 n420 VDD VSS ND3D8
XU426 n454 n220 VDD VSS INVD6
XU427 n627 n318 VDD VSS INVD1
XU428 n481 n329 n205 VDD VSS AN2D4
XU429 n330 n329 VDD VSS CKND2
XU430 FE_OCPN1149_core_value_23 n459 n208 VDD VSS AN2XD1
XU432 n187 n199 n468 VDD VSS CKND2D2
XU433 n467 n201 n200 VDD VSS ND2D2
XU436 n636 n637 VDD VSS INVD1
XU437 n634 n456 n436 VDD VSS XNR2D0
XU438 n266 n383 n274 n277 n460 VDD VSS ND4D1
XU439 n265 n435 n456 VDD VSS OR2D1
XU440 n268 n379 n435 VDD VSS OR2D1
XU441 n396 N67 n397 VDD VSS XNR2D0
XU442 n459 n191 VDD VSS INVD1
XU443 n263 n264 VDD VSS INVD1
XU444 n407 N66 n408 VDD VSS XNR2D0
XU445 n405 n279 n406 VDD VSS XNR2D0
XU446 n345 n270 n346 VDD VSS XNR2D0
XU447 N64 n356 n360 VDD VSS XNR2D0
XU448 FE_OFN0_x_31 FE_OFN27_y_31 n526 eco_net VDD VSS AOI21D0
XU449 n312 n341 VDD VSS INVD1
XU450 n640 n210 VDD VSS INVD1
XU451 n520 n515 VDD VSS INVD1
XU452 n488 n524 VDD VSS INVD1
XU453 n478 n477 n485 n479 VDD VSS OAI21D1
XU454 FE_OFN31_y_27 n518 VDD VSS INVD1
XU456 FE_OFN30_y_28 n519 VDD VSS INVD1
XU457 FE_OFN28_y_30 n523 VDD VSS INVD1
XU459 core_value[25] core_value[24] core_value[23] n193 VDD VSS NR3D4
XU460 n431 FE_OFN60_n198 n433 VDD VSS INR2D2
XU462 n327 FE_OCPN1140_n229 n197 VDD VSS NR2XD4
XU463 n190 n195 n418 VDD VSS CKND2D8
XU464 n341 FE_OFN60_n198 n195 VDD VSS INR2D4
XU465 n196 n328 n641 VDD VSS INR2D4
XU467 n166 n397 n398 VDD VSS CKND2D4
XU468 FE_RN_9 n408 n409 VDD VSS CKND2D4
XU469 n415 n653 VDD VSS INVD6
XU470 FE_RN_6 FE_RN_7 n335 VDD VSS NR2XD4
XU475 n529 n249 VDD VSS INVD1
XU476 n166 n384 n388 VDD VSS CKND2D4
XU479 n469 FE_RN_14 FE_OCPN1455_n204 n481 VDD VSS ND3D3
XU480 core_value[27] core_value[26] n204 VDD VSS NR2D8
XU481 n288 n572 result[10] VDD VSS NR2D3
XU482 n288 n604 result[17] VDD VSS NR2D3
XU483 n629 n617 result[20] VDD VSS NR2XD2
XU484 n629 n555 result[6] VDD VSS NR2XD2
XU485 FE_OCPN1387_n427 n513 VDD VSS INVD4
XU486 FE_OFN61_n216 n630 VDD VSS CKND4
XU489 n637 n219 n213 VDD VSS INR2D1
XU490 x[1] n303 VDD VSS INVD2
XU491 core_value[22] core_value[24] n215 VDD VSS NR2D8
XU493 FE_OCPN3435_n158 n393 FE_OCPN3453_FE_RN_8 n392 n400 VDD VSS AOI22D4
XU494 n164 n371 FE_OCPN3453_FE_RN_8 n370 n378 VDD VSS AOI22D4
XU496 FE_OCPN1239_n165 n638 n540 VDD VSS ND2D3
XU500 n521 n225 VDD VSS INVD0
XU501 n523 n226 VDD VSS INVD0
XU503 n318 n231 VDD VSS INVD3
XU504 n318 n232 VDD VSS CKND2
XU508 FE_OFN2778_y_3 n235 VDD VSS INVD0
XU509 n235 n236 VDD VSS INVD0
XU510 FE_OCPN3448_x_3 n237 VDD VSS INVD0
XU511 n237 n238 VDD VSS INVD0
XU512 FE_OCPN1307_n668 n240 VDD VSS INVD0
XU513 n240 n241 VDD VSS INVD0
XU515 FE_OFN25_x_2 n243 VDD VSS INVD0
XU516 n243 n244 VDD VSS INVD0
XU517 n327 n432 VDD VSS INVD6
XU518 FE_OFN51_y_6 n251 VDD VSS INVD0
XU519 n251 n252 VDD VSS INVD0
XU520 FE_OCPN1419_FE_OFN1121_divide_mode n253 VDD VSS INVD0
XU521 n253 n254 VDD VSS INVD1
XU522 FE_OFN3407_n n255 VDD VSS INVD0
XU523 n255 n256 VDD VSS INVD0
XU524 FE_OFN2783_y_8 n257 VDD VSS INVD0
XU525 n257 n258 VDD VSS INVD0
XU526 n263 n265 VDD VSS INVD0
XU527 n269 n270 VDD VSS INVD0
XU528 FE_OFN3408_y_17 n273 VDD VSS INVD0
XU529 n427 FE_OFN63_n531 n286 VDD VSS ND2D4
XU530 n427 FE_OFN63_n531 n287 VDD VSS CKND2D4
XU531 n227 FE_OCPN1154_n531 n288 VDD VSS ND2D4
XU534 FE_OFN46_y_11 n291 VDD VSS INVD0
XU535 n291 n292 VDD VSS INVD0
XU536 FE_OFN1126_x_0 n293 VDD VSS INVD0
XU537 n293 n294 VDD VSS INVD0
XU538 FE_OCPN3447_y_4 n295 VDD VSS INVD0
XU539 n295 n296 VDD VSS INVD0
XU540 FE_OFN1125_y_5 n297 VDD VSS INVD0
XU541 n297 n298 VDD VSS INVD0
XU542 FE_OFN48_y_9 n310 VDD VSS INVD0
XU543 n633 n312 VDD VSS INVD1
XU544 n633 n313 VDD VSS INVD0
XU548 n228 n319 VDD VSS INVD2
XU549 n228 n320 VDD VSS CKND2
XU550 n228 n321 VDD VSS CKND2
XU551 n228 n322 VDD VSS INVD2
XU555 n583 n582 n324 n591 n574 VDD VSS OAI22D2
XU556 n583 n565 n324 n573 n557 VDD VSS OAI22D2
XU557 FE_RN_15 n346 n347 VDD VSS CKND2D4
XU558 core_value[8] core_value[7] n462 core_value[6] n463 VDD VSS NR4D1
XU561 FE_OCPN3451_FE_RN_8 n341 n416 VDD VSS ND2D4
XU562 n522 n520 VDD VSS CKBD1
XU563 n282 n285 n368 VDD VSS OR2D0
XU564 n357 n281 n372 VDD VSS OR2D0
XU565 n372 n270 n344 VDD VSS XNR2D0
XU566 n285 n311 n356 VDD VSS OR2D0
XU567 n356 n282 n345 VDD VSS OR2D0
XU568 n285 n312 n350 n362 VDD VSS HA1D0
XU569 n284 n311 n352 n357 VDD VSS HA1D0
XU570 N64 n357 n358 VDD VSS XNR2D0
XU571 n362 n282 n363 n369 VDD VSS HA1D0
XU572 n155 n363 n364 VDD VSS ND2D8
XU573 n270 n368 n401 VDD VSS OR2D0
XU574 n279 n401 n390 VDD VSS OR2D0
XU575 N65 n372 n405 VDD VSS OR2D0
XU576 n278 n405 n394 VDD VSS OR2D0
XU577 n385 n267 n373 VDD VSS XNR2D0
XU578 n190 FE_OFN1356_n198 n373 n377 VDD VSS ND3D8
XU579 n270 n281 n313 n284 n383 VDD VSS NR4D0
XU580 n383 n407 VDD VSS INVD0
XU581 n278 n407 n396 VDD VSS OR2D0
XU582 n275 n396 n374 VDD VSS OR2D0
XU583 n374 n267 n375 VDD VSS XNR2D0
XU584 FE_RN_9 n375 n376 VDD VSS CKND2D4
XU585 n380 n268 n370 n437 VDD VSS HA1D0
XU586 n460 n265 n384 VDD VSS XNR2D0
XU587 n430 n265 n386 VDD VSS XNR2D0
XU588 n391 n276 n392 n380 VDD VSS HA1D0
XU589 n394 n276 n395 VDD VSS XNR2D0
XU590 n415 n412 n413 n414 n424 VDD VSS ND4D4
XU591 n271 n281 N63 n311 n428 VDD VSS ND4D0
XU593 n634 n455 n431 VDD VSS XNR2D0
XU594 n166 n191 n433 n432 n434 VDD VSS AOI22D4
XU595 n437 n264 n381 n635 VDD VSS HA1D0
XU596 FE_OFN8_x_23 FE_OFN7_x_24 FE_OFN6_x_25 FE_OFN5_x_26 n442 VDD VSS AN4D0
XU597 FE_OFN4_x_27 FE_OFN3_x_28 FE_OFN2_x_29 FE_OFN1_x_30 n441 VDD VSS AN4D0
XU598 FE_OFN31_y_27 FE_OFN30_y_28 n470 VDD VSS NR2D0
XU599 FE_OFN28_y_30 n225 n445 VDD VSS NR2D0
XU600 FE_OFN34_y_24 FE_OFN35_y_23 n444 VDD VSS NR2D0
XU601 FE_OFN32_y_26 FE_OFN33_y_25 n443 VDD VSS NR2D0
XU602 FE_OFN32_y_26 FE_OFN33_y_25 n447 VDD VSS CKND2D0
XU603 FE_OFN34_y_24 FE_OFN35_y_23 n446 VDD VSS CKND2D0
XU604 FE_OFN28_y_30 FE_OFN29_y_29 n448 VDD VSS CKND2D0
XU605 FE_OFN31_y_27 FE_OFN30_y_28 n472 VDD VSS CKND2D0
XU606 n448 n472 n449 VDD VSS NR2D0
XU607 n502 n493 n522 n499 VDD VSS MUX2ND0
XU608 n450 n619 n484 VDD VSS NR2XD0
XU609 FE_OCPN1314_n332 n245 n453 VDD VSS ND2D1
XU610 n169 n638 n451 VDD VSS ND2D3
XU612 n540 n535 VDD VSS CKND2
XU613 n535 n596 VDD VSS INVD4
XU616 core_value[14] core_value[13] n466 VDD VSS NR2XD2
XU617 core_value[3] core_value[2] core_value[1] core_value[0] n461 VDD VSS
+ NR4D0
XU618 core_value[4] n461 n560 n462 VDD VSS IND3D1
XU620 n463 n224 n464 VDD VSS CKND2D2
XU622 FE_OFN34_y_24 FE_OFN35_y_23 FE_OFN32_y_26 FE_OFN29_y_29 n471 VDD VSS
+ NR4D0
XU623 n471 n470 n527 FE_OFN28_y_30 n478 VDD VSS AOI31D0
XU624 n472 n473 VDD VSS INVD0
XU625 n474 FE_OFN29_y_29 n473 n523 n477 VDD VSS AOI31D0
XU626 FE_OFN5_x_26 FE_OFN3_x_28 FE_OFN1_x_30 FE_OFN2_x_29 n476 VDD VSS NR4D0
XU627 FE_OFN7_x_24 FE_OFN6_x_25 FE_OFN4_x_27 FE_OFN8_x_23 n475 VDD VSS NR4D0
XU629 n485 n498 VDD VSS INVD0
XU630 FE_OFN2779_y_22 FE_OFN38_y_20 n310 FE_OFN47_y_10 n487 VDD VSS NR4D0
XU631 n173 FE_OFN39_y_19 n273 FE_OFN2730_y_21 n486 VDD VSS NR4D0
XU632 n507 n488 n487 n486 n496 VDD VSS OAI211D0
XU633 n241 n296 FE_OCPN1300_n666 n492 VDD VSS NR3D0
XU634 n298 n236 n256 n258 n491 VDD VSS NR4D0
XU635 n252 FE_OFN40_y_18 FE_OFN45_y_12 n305 n490 VDD VSS NR4D0
XU636 FE_OFN44_y_14 n292 FE_OFN41_y_16 FE_OFN42_y_15 n489 VDD VSS NR4D0
XU637 n492 n491 n490 n489 n495 VDD VSS ND4D0
XU638 n493 n494 VDD VSS INVD0
XU639 FE_OFN2801_x_22 FE_OFN11_x_20 n308 n183 n504 VDD VSS NR4D0
XU640 n238 n294 FE_OFN2723_x_4 n501 VDD VSS NR3D0
XU641 n304 FE_OFN2784_x_7 n176 n301 n500 VDD VSS NR4D0
XU642 n524 n502 n501 n500 n503 VDD VSS OAI211D0
XU643 n504 n503 n510 VDD VSS INR2D0
XU644 FE_OFN2740_x_19 n178 FE_OFN2736_x_17 FE_OFN2751_x_21 n509 VDD VSS NR4D0
XU645 n186 n179 FE_OFN14_x_16 FE_OFN2737_x_14 n506 VDD VSS NR4D0
XU646 n244 n671 FE_OFN2793_x_6 FE_OFN2729_x_8 n505 VDD VSS NR4D0
XU647 n506 n505 n508 VDD VSS CKAN2D0
XU648 n510 n509 n508 n507 n511 VDD VSS AOI31D0
XU650 n514 DP_OP_58J2_123_7635_n43 DP_OP_58J2_123_7635_n10 VDD VSS OR2D0
XU651 FE_OFN34_y_24 n517 VDD VSS INVD0
XU652 n517 n524 n659 VDD VSS CKAN2D0
XU653 FE_OFN29_y_29 n521 VDD VSS INVD1
XU654 FE_OFN0_x_31 FE_OFN27_y_31 n525 n526 VDD VSS OAI21D0
XU655 n527 n254 n660 VDD VSS CKAN2D0
XU656 n528 n254 n661 VDD VSS CKAN2D0
XU657 FE_OFN96_n286 n532 result[0] VDD VSS NR2D8
XU659 core_value[2] n548 VDD VSS INVD1
XU660 n596 n539 n326 n548 n533 VDD VSS OAI22D4
XU661 n319 core_value[1] n533 n534 VDD VSS AOI21D1
XU663 n561 n601 VDD VSS INVD2
XU664 core_value[1] n544 VDD VSS INVD1
XU665 core_value[3] n552 VDD VSS INVD1
XU666 n601 n544 n234 n552 n537 VDD VSS OAI22D2
XU667 core_value[2] n232 n537 n536 n538 VDD VSS AOI211D2
XU668 FE_OFN1358_n287 n538 result[2] VDD VSS NR2D4
XU669 n544 n230 n289 n539 n542 VDD VSS OAI22D2
XU671 n561 n624 VDD VSS INVD2
XU673 n624 n548 n323 n556 n541 VDD VSS OAI22D1
XU675 n288 n543 result[3] VDD VSS NR2D4
XU676 n548 n316 n290 n544 n546 VDD VSS OAI22D1
XU677 n624 n552 n622 FE_OFN2763_core_value_5 n545 VDD VSS OAI22D1
XU678 n322 core_value[4] n546 n545 n547 VDD VSS AOI211D2
XU679 n159 n547 result[4] VDD VSS NR2D4
XU680 n317 n552 n174 n548 n550 VDD VSS OAI22D2
XU682 FE_OFN96_n286 n551 result[5] VDD VSS NR2D8
XU684 n624 FE_OFN2763_core_value_5 n325 n569 n553 VDD VSS OAI22D1
XU685 n317 FE_OFN2763_core_value_5 n246 n556 n558 VDD VSS OAI22D2
XU686 n561 n583 VDD VSS INVD2
XU688 n315 n565 n246 FE_OFN2763_core_value_5 n563 VDD VSS OAI22D2
XU689 n161 n569 FE_PSN1656_n323 n224 n562 VDD VSS OAI22D2
XU690 n159 n564 result[8] VDD VSS NR2D3
XU691 n317 n569 n174 n565 n567 VDD VSS OAI22D1
XU693 n160 n573 n325 n582 n566 VDD VSS OAI22D2
XU694 n159 n568 result[9] VDD VSS NR2D3
XU696 FE_PSN1629_n601 n224 n323 n587 n570 VDD VSS OAI22D2
XU699 n315 n582 n577 n289 n580 VDD VSS OAI22D2
XU701 n161 n587 n326 n595 n579 VDD VSS OAI22D2
XU702 n159 n581 result[12] VDD VSS NR2D3
XU703 FE_PSN1645_n316 n587 n174 n582 n585 VDD VSS OAI22D2
XU704 core_value[14] n600 VDD VSS INVD1
XU705 n583 n591 n622 n600 n584 VDD VSS OAI22D2
XU707 n316 n591 n247 n587 n589 VDD VSS OAI22D2
XU708 n601 n595 n323 n605 n588 VDD VSS OAI22D1
XU709 n288 n590 result[14] VDD VSS NR2D3
XU710 n315 n595 n290 n591 n593 VDD VSS OAI22D2
XU712 n596 n600 n234 n609 n592 VDD VSS OAI22D2
XU713 FE_PSN1631_n287 n594 result[15] VDD VSS NR2D4
XU716 core_value[18] n618 VDD VSS INVD1
XU717 n601 n609 n234 n618 n602 VDD VSS OAI22D1
XU718 n230 n609 n221 n247 n607 VDD VSS OAI22D2
XU719 n583 n613 n622 n619 n606 VDD VSS OAI22D1
XU720 FE_OCPN3503_n287 n608 result[18] VDD VSS NR2D4
XU721 n160 n618 n325 n623 n610 VDD VSS OAI22D2
XU723 n230 n618 n247 n613 n616 VDD VSS OAI22D2
XU724 n160 n619 n326 FE_OFN3403_n242 n615 VDD VSS OAI22D2
XU727 n624 n623 n326 FE_OCPN1159_n332 n625 VDD VSS OAI22D1
XU728 n614 n231 n626 n625 n628 VDD VSS AOI211D4
XU729 n629 n628 result[21] VDD VSS NR2XD3
XU730 FE_OCPN1189_n631 n632 VDD VSS INVD1
XU731 n262 n313 n632 n642 VDD VSS IOA21D1
XU732 n635 n634 n438 n636 VDD VSS HA1D0
XU733 n249 n642 n260 result[23] VDD VSS IOA21D2
XU734 n656 n284 n643 n644 VDD VSS IOA21D2
XU736 n249 n646 n260 result[25] VDD VSS IOA21D2
XU737 n656 n271 FE_RN_11 n648 VDD VSS IOA21D1
XU738 n656 n278 FE_OCPN1295_n649 n650 VDD VSS IOA21D2
XU739 n249 n650 n261 result[27] VDD VSS IOA21D4
XU740 n250 n652 n261 result[28] VDD VSS IOA21D4
XU741 n250 n654 n261 result[29] VDD VSS IOA21D2
XU742 n262 n265 n655 n657 VDD VSS IOA21D1
XU743 n664 DP_OP_58J2_123_7635_n49 DP_OP_58J2_123_7635_n5 N68
+ DP_OP_58J2_123_7635_n4 VDD VSS FA1D0
XU744 n663 DP_OP_58J2_123_7635_n48 DP_OP_58J2_123_7635_n6 N67
+ DP_OP_58J2_123_7635_n5 VDD VSS FA1D0
XU745 n662 DP_OP_58J2_123_7635_n47 DP_OP_58J2_123_7635_n7 N66
+ DP_OP_58J2_123_7635_n6 VDD VSS FA1D0
XU746 n661 DP_OP_58J2_123_7635_n46 DP_OP_58J2_123_7635_n8 N65
+ DP_OP_58J2_123_7635_n7 VDD VSS FA1D0
XU747 n660 DP_OP_58J2_123_7635_n45 DP_OP_58J2_123_7635_n9 N64
+ DP_OP_58J2_123_7635_n8 VDD VSS FA1D0
XU748 n659 DP_OP_58J2_123_7635_n44 DP_OP_58J2_123_7635_n10 N63
+ DP_OP_58J2_123_7635_n9 VDD VSS FA1D0
XU eco_net eco_net_0 VDD VSS BUFFD0
XU0 eco_net_0 result[31] VDD VSS BUFFD0
XFILLER_T_4_723 VDD VSS DCAP16
XFILLER_T_4_713 VDD VSS DCAP4
XFILLER_T_4_712 VDD VSS DCAP8
XFILLER_T_4_707 VDD VSS DCAP4
XFILLER_T_4_698 VDD VSS DCAP8
XFILLER_T_4_694 VDD VSS DCAP4
XFILLER_T_4_686 VDD VSS DCAP4
XFILLER_T_4_679 VDD VSS DCAP8
XFILLER_T_4_678 VDD VSS DCAP16
XFILLER_T_4_674 VDD VSS DCAP4
XFILLER_T_4_671 VDD VSS DCAP4
XFILLER_T_4_670 VDD VSS DCAP8
XFILLER_T_4_669 VDD VSS DCAP4
XFILLER_T_4_659 VDD VSS DCAP4
XFILLER_T_4_655 VDD VSS DCAP8
XFILLER_T_4_654 VDD VSS DCAP8
XFILLER_T_4_651 VDD VSS DCAP8
XFILLER_T_4_640 VDD VSS DCAP4
XFILLER_T_4_623 VDD VSS DCAP8
XFILLER_T_4_622 VDD VSS DCAP4
XFILLER_T_4_618 VDD VSS DCAP4
XFILLER_T_4_615 VDD VSS DCAP4
XFILLER_T_4_609 VDD VSS DCAP8
XFILLER_T_4_605 VDD VSS DCAP4
XFILLER_T_4_603 VDD VSS DCAP16
XFILLER_T_4_602 VDD VSS DCAP8
XFILLER_T_4_587 VDD VSS DCAP4
XFILLER_T_4_584 VDD VSS DCAP4
XFILLER_T_4_583 VDD VSS DCAP16
XFILLER_T_4_580 VDD VSS DCAP8
XFILLER_T_4_579 VDD VSS DCAP4
XFILLER_T_4_568 VDD VSS DCAP4
XFILLER_T_4_562 VDD VSS DCAP4
XFILLER_T_4_555 VDD VSS DCAP8
XFILLER_T_4_550 VDD VSS DCAP16
XFILLER_T_4_542 VDD VSS DCAP4
XFILLER_T_4_537 VDD VSS DCAP8
XFILLER_T_4_534 VDD VSS DCAP4
XFILLER_T_4_532 VDD VSS DCAP4
XFILLER_T_4_528 VDD VSS DCAP4
XFILLER_T_4_523 VDD VSS DCAP8
XFILLER_T_4_521 VDD VSS DCAP8
XFILLER_T_4_506 VDD VSS DCAP32
XFILLER_T_4_502 VDD VSS DCAP4
XFILLER_T_4_497 VDD VSS DCAP8
XFILLER_T_4_492 VDD VSS DCAP8
XFILLER_T_4_490 VDD VSS DCAP4
XFILLER_T_4_485 VDD VSS DCAP8
XFILLER_T_4_484 VDD VSS DCAP4
XFILLER_T_4_476 VDD VSS DCAP4
XFILLER_T_4_466 VDD VSS DCAP4
XFILLER_T_4_464 VDD VSS DCAP4
XFILLER_T_4_457 VDD VSS DCAP4
XFILLER_T_4_448 VDD VSS DCAP8
XFILLER_T_4_447 VDD VSS DCAP4
XFILLER_T_4_446 VDD VSS DCAP8
XFILLER_T_4_444 VDD VSS DCAP4
XFILLER_T_4_442 VDD VSS DCAP4
XFILLER_T_4_437 VDD VSS DCAP4
XFILLER_T_4_434 VDD VSS DCAP4
XFILLER_T_4_433 VDD VSS DCAP4
XFILLER_T_4_431 VDD VSS DCAP4
XFILLER_T_4_429 VDD VSS DCAP4
XFILLER_T_4_423 VDD VSS DCAP4
XFILLER_T_4_421 VDD VSS DCAP4
XFILLER_T_4_416 VDD VSS DCAP8
XFILLER_T_4_412 VDD VSS DCAP8
XFILLER_T_4_406 VDD VSS DCAP4
XFILLER_T_4_404 VDD VSS DCAP4
XFILLER_T_4_397 VDD VSS DCAP4
XFILLER_T_4_394 VDD VSS DCAP4
XFILLER_T_4_390 VDD VSS DCAP4
XFILLER_T_4_389 VDD VSS DCAP8
XFILLER_T_4_381 VDD VSS DCAP4
XFILLER_T_4_379 VDD VSS DCAP4
XFILLER_T_4_367 VDD VSS DCAP4
XFILLER_T_4_364 VDD VSS DCAP8
XFILLER_T_4_360 VDD VSS DCAP8
XFILLER_T_4_357 VDD VSS DCAP4
XFILLER_T_4_352 VDD VSS DCAP8
XFILLER_T_4_351 VDD VSS DCAP8
XFILLER_T_4_346 VDD VSS DCAP32
XFILLER_T_4_342 VDD VSS DCAP4
XFILLER_T_4_338 VDD VSS DCAP8
XFILLER_T_4_328 VDD VSS DCAP4
XFILLER_T_4_326 VDD VSS DCAP4
XFILLER_T_4_321 VDD VSS DCAP4
XFILLER_T_4_315 VDD VSS DCAP4
XFILLER_T_4_306 VDD VSS DCAP4
XFILLER_T_4_295 VDD VSS DCAP8
XFILLER_T_4_287 VDD VSS DCAP4
XFILLER_T_4_286 VDD VSS DCAP16
XFILLER_T_4_276 VDD VSS DCAP4
XFILLER_T_4_274 VDD VSS DCAP4
XFILLER_T_4_272 VDD VSS DCAP8
XFILLER_T_4_269 VDD VSS DCAP8
XFILLER_T_4_266 VDD VSS DCAP4
XFILLER_T_4_264 VDD VSS DCAP4
XFILLER_T_4_258 VDD VSS DCAP16
XFILLER_T_4_255 VDD VSS DCAP4
XFILLER_T_4_245 VDD VSS DCAP8
XFILLER_T_4_243 VDD VSS DCAP8
XFILLER_T_4_240 VDD VSS DCAP4
XFILLER_T_4_239 VDD VSS DCAP8
XFILLER_T_4_232 VDD VSS DCAP4
XFILLER_T_4_225 VDD VSS DCAP4
XFILLER_T_4_203 VDD VSS DCAP4
XFILLER_T_4_195 VDD VSS DCAP4
XFILLER_T_4_187 VDD VSS DCAP4
XFILLER_T_5_382 VDD VSS DCAP4
XFILLER_T_5_381 VDD VSS DCAP8
XFILLER_T_5_380 VDD VSS DCAP32
XFILLER_T_5_379 VDD VSS DCAP64
XFILLER_T_4_180 VDD VSS DCAP4
XFILLER_T_5_378 VDD VSS DCAP64
XFILLER_T_5_377 VDD VSS DCAP64
XFILLER_T_5_376 VDD VSS DCAP64
XFILLER_T_5_375 VDD VSS DCAP64
XFILLER_T_5_374 VDD VSS DCAP64
XFILLER_T_5_373 VDD VSS DCAP64
XFILLER_T_4_177 VDD VSS DCAP4
XFILLER_T_5_370 VDD VSS DCAP8
XFILLER_T_5_369 VDD VSS DCAP16
XFILLER_T_5_367 VDD VSS DCAP4
XFILLER_T_5_366 VDD VSS DCAP32
XFILLER_T_5_365 VDD VSS DCAP64
XFILLER_T_5_364 VDD VSS DCAP64
XFILLER_T_5_363 VDD VSS DCAP64
XFILLER_T_5_362 VDD VSS DCAP64
XFILLER_T_5_361 VDD VSS DCAP64
XFILLER_T_5_360 VDD VSS DCAP64
XFILLER_T_5_359 VDD VSS DCAP64
XFILLER_T_5_358 VDD VSS DCAP64
XFILLER_T_5_356 VDD VSS DCAP4
XFILLER_T_5_355 VDD VSS DCAP32
XFILLER_T_5_354 VDD VSS DCAP64
XFILLER_T_5_353 VDD VSS DCAP64
XFILLER_T_5_352 VDD VSS DCAP64
XFILLER_T_4_168 VDD VSS DCAP4
XFILLER_T_5_351 VDD VSS DCAP64
XFILLER_T_5_350 VDD VSS DCAP64
XFILLER_T_5_349 VDD VSS DCAP64
XFILLER_T_5_348 VDD VSS DCAP64
XFILLER_T_4_166 VDD VSS DCAP4
XFILLER_T_5_347 VDD VSS DCAP64
XFILLER_T_5_345 VDD VSS DCAP4
XFILLER_T_5_344 VDD VSS DCAP32
XFILLER_T_4_164 VDD VSS DCAP8
XFILLER_T_5_343 VDD VSS DCAP64
XFILLER_T_5_342 VDD VSS DCAP64
XFILLER_T_5_341 VDD VSS DCAP64
XFILLER_T_5_340 VDD VSS DCAP64
XFILLER_T_5_339 VDD VSS DCAP64
XFILLER_T_5_338 VDD VSS DCAP64
XFILLER_T_5_337 VDD VSS DCAP64
XFILLER_T_5_336 VDD VSS DCAP64
XFILLER_T_5_334 VDD VSS DCAP4
XFILLER_T_5_333 VDD VSS DCAP32
XFILLER_T_5_332 VDD VSS DCAP64
XFILLER_T_5_331 VDD VSS DCAP64
XFILLER_T_5_330 VDD VSS DCAP64
XFILLER_T_5_329 VDD VSS DCAP64
XFILLER_T_5_328 VDD VSS DCAP64
XFILLER_T_5_327 VDD VSS DCAP64
XFILLER_T_5_326 VDD VSS DCAP64
XFILLER_T_5_325 VDD VSS DCAP64
XFILLER_T_5_323 VDD VSS DCAP4
XFILLER_T_5_322 VDD VSS DCAP32
XFILLER_T_5_321 VDD VSS DCAP64
XFILLER_T_5_320 VDD VSS DCAP64
XFILLER_T_5_319 VDD VSS DCAP64
XFILLER_T_5_318 VDD VSS DCAP64
XFILLER_T_5_317 VDD VSS DCAP64
XFILLER_T_5_316 VDD VSS DCAP64
XFILLER_T_5_315 VDD VSS DCAP64
XFILLER_T_5_314 VDD VSS DCAP64
XFILLER_T_5_312 VDD VSS DCAP4
XFILLER_T_5_311 VDD VSS DCAP32
XFILLER_T_5_310 VDD VSS DCAP64
XFILLER_T_5_309 VDD VSS DCAP64
XFILLER_T_5_308 VDD VSS DCAP64
XFILLER_T_4_150 VDD VSS DCAP4
XFILLER_T_5_307 VDD VSS DCAP64
XFILLER_T_5_306 VDD VSS DCAP64
XFILLER_T_4_149 VDD VSS DCAP32
XFILLER_T_5_305 VDD VSS DCAP64
XFILLER_T_5_304 VDD VSS DCAP64
XFILLER_T_5_303 VDD VSS DCAP64
XFILLER_T_5_301 VDD VSS DCAP4
XFILLER_T_5_300 VDD VSS DCAP32
XFILLER_T_5_299 VDD VSS DCAP64
XFILLER_T_5_298 VDD VSS DCAP64
XFILLER_T_5_297 VDD VSS DCAP64
XFILLER_T_5_296 VDD VSS DCAP64
XFILLER_T_5_295 VDD VSS DCAP64
XFILLER_T_5_294 VDD VSS DCAP64
XFILLER_T_5_293 VDD VSS DCAP64
XFILLER_T_5_292 VDD VSS DCAP64
XFILLER_T_5_290 VDD VSS DCAP4
XFILLER_T_5_289 VDD VSS DCAP32
XFILLER_T_5_288 VDD VSS DCAP64
XFILLER_T_5_287 VDD VSS DCAP64
XFILLER_T_5_286 VDD VSS DCAP64
XFILLER_T_5_285 VDD VSS DCAP64
XFILLER_T_5_284 VDD VSS DCAP64
XFILLER_T_5_283 VDD VSS DCAP64
XFILLER_T_5_282 VDD VSS DCAP64
XFILLER_T_5_281 VDD VSS DCAP64
XFILLER_T_5_279 VDD VSS DCAP4
XFILLER_T_5_278 VDD VSS DCAP32
XFILLER_T_4_140 VDD VSS DCAP4
XFILLER_T_5_277 VDD VSS DCAP64
XFILLER_T_4_139 VDD VSS DCAP8
XFILLER_T_5_276 VDD VSS DCAP64
XFILLER_T_5_275 VDD VSS DCAP64
XFILLER_T_5_274 VDD VSS DCAP64
XFILLER_T_5_273 VDD VSS DCAP64
XFILLER_T_5_272 VDD VSS DCAP64
XFILLER_T_5_271 VDD VSS DCAP64
XFILLER_T_5_270 VDD VSS DCAP64
XFILLER_T_5_268 VDD VSS DCAP4
XFILLER_T_5_267 VDD VSS DCAP32
XFILLER_T_5_266 VDD VSS DCAP64
XFILLER_T_5_265 VDD VSS DCAP64
XFILLER_T_5_264 VDD VSS DCAP64
XFILLER_T_5_263 VDD VSS DCAP64
XFILLER_T_5_262 VDD VSS DCAP64
XFILLER_T_5_261 VDD VSS DCAP64
XFILLER_T_4_134 VDD VSS DCAP4
XFILLER_T_5_260 VDD VSS DCAP64
XFILLER_T_5_259 VDD VSS DCAP64
XFILLER_T_5_257 VDD VSS DCAP4
XFILLER_T_5_256 VDD VSS DCAP32
XFILLER_T_5_255 VDD VSS DCAP64
XFILLER_T_5_254 VDD VSS DCAP64
XFILLER_T_4_132 VDD VSS DCAP4
XFILLER_T_5_253 VDD VSS DCAP64
XFILLER_T_5_252 VDD VSS DCAP64
XFILLER_T_4_131 VDD VSS DCAP4
XFILLER_T_5_251 VDD VSS DCAP64
XFILLER_T_5_250 VDD VSS DCAP64
XFILLER_T_5_249 VDD VSS DCAP64
XFILLER_T_5_248 VDD VSS DCAP64
XFILLER_T_5_246 VDD VSS DCAP4
XFILLER_T_5_245 VDD VSS DCAP32
XFILLER_T_5_244 VDD VSS DCAP64
XFILLER_T_5_243 VDD VSS DCAP64
XFILLER_T_5_242 VDD VSS DCAP64
XFILLER_T_5_241 VDD VSS DCAP64
XFILLER_T_5_240 VDD VSS DCAP64
XFILLER_T_5_239 VDD VSS DCAP64
XFILLER_T_5_238 VDD VSS DCAP64
XFILLER_T_5_237 VDD VSS DCAP64
XFILLER_T_5_235 VDD VSS DCAP4
XFILLER_T_5_234 VDD VSS DCAP32
XFILLER_T_5_233 VDD VSS DCAP64
XFILLER_T_5_232 VDD VSS DCAP64
XFILLER_T_5_231 VDD VSS DCAP64
XFILLER_T_5_230 VDD VSS DCAP64
XFILLER_T_5_229 VDD VSS DCAP64
XFILLER_T_5_228 VDD VSS DCAP64
XFILLER_T_5_227 VDD VSS DCAP64
XFILLER_T_5_226 VDD VSS DCAP64
XFILLER_T_5_224 VDD VSS DCAP4
XFILLER_T_5_223 VDD VSS DCAP32
XFILLER_T_5_222 VDD VSS DCAP64
XFILLER_T_5_221 VDD VSS DCAP64
XFILLER_T_5_220 VDD VSS DCAP64
XFILLER_T_5_219 VDD VSS DCAP64
XFILLER_T_5_218 VDD VSS DCAP64
XFILLER_T_5_217 VDD VSS DCAP64
XFILLER_T_5_216 VDD VSS DCAP64
XFILLER_T_5_215 VDD VSS DCAP64
XFILLER_T_5_213 VDD VSS DCAP4
XFILLER_T_5_212 VDD VSS DCAP32
XFILLER_T_5_211 VDD VSS DCAP64
XFILLER_T_5_210 VDD VSS DCAP64
XFILLER_T_4_115 VDD VSS DCAP4
XFILLER_T_5_209 VDD VSS DCAP64
XFILLER_T_4_114 VDD VSS DCAP8
XFILLER_T_5_208 VDD VSS DCAP64
XFILLER_T_5_207 VDD VSS DCAP64
XFILLER_T_5_206 VDD VSS DCAP64
XFILLER_T_5_205 VDD VSS DCAP64
XFILLER_T_5_204 VDD VSS DCAP64
XFILLER_T_5_203 VDD VSS DCAP4
XFILLER_T_5_202 VDD VSS DCAP8
XFILLER_T_5_201 VDD VSS DCAP16
XFILLER_T_5_200 VDD VSS DCAP64
XFILLER_T_5_195 VDD VSS DCAP4
XFILLER_T_5_194 VDD VSS DCAP16
XFILLER_T_5_193 VDD VSS DCAP32
XFILLER_T_5_192 VDD VSS DCAP4
XFILLER_T_5_191 VDD VSS DCAP8
XFILLER_T_4_105 VDD VSS DCAP4
XFILLER_T_5_185 VDD VSS DCAP32
XFILLER_T_5_184 VDD VSS DCAP64
XFILLER_T_5_183 VDD VSS DCAP64
XFILLER_T_5_182 VDD VSS DCAP64
XFILLER_T_5_180 VDD VSS DCAP8
XFILLER_T_5_179 VDD VSS DCAP32
XFILLER_T_4_100 VDD VSS DCAP4
XFILLER_T_5_171 VDD VSS DCAP4
XFILLER_T_5_170 VDD VSS DCAP8
XFILLER_T_5_165 VDD VSS DCAP4
XFILLER_T_5_164 VDD VSS DCAP8
XFILLER_T_5_159 VDD VSS DCAP8
XFILLER_T_4_90 VDD VSS DCAP4
XFILLER_T_5_158 VDD VSS DCAP16
XFILLER_T_5_157 VDD VSS DCAP64
XFILLER_T_5_156 VDD VSS DCAP64
XFILLER_T_5_155 VDD VSS DCAP64
XFILLER_T_5_153 VDD VSS DCAP8
XFILLER_T_4_85 VDD VSS DCAP4
XFILLER_T_5_148 VDD VSS DCAP4
XFILLER_T_5_145 VDD VSS DCAP4
XFILLER_T_5_143 VDD VSS DCAP4
XFILLER_T_5_142 VDD VSS DCAP8
XFILLER_T_5_141 VDD VSS DCAP8
XFILLER_T_5_138 VDD VSS DCAP4
XFILLER_T_5_135 VDD VSS DCAP4
XFILLER_T_5_131 VDD VSS DCAP8
XFILLER_T_5_130 VDD VSS DCAP16
XFILLER_T_5_129 VDD VSS DCAP32
XFILLER_T_4_76 VDD VSS DCAP4
XFILLER_T_5_128 VDD VSS DCAP64
XFILLER_T_5_127 VDD VSS DCAP64
XFILLER_T_5_124 VDD VSS DCAP32
XFILLER_T_5_123 VDD VSS DCAP4
XFILLER_T_5_120 VDD VSS DCAP16
XFILLER_T_5_119 VDD VSS DCAP32
XFILLER_T_5_118 VDD VSS DCAP64
XFILLER_T_5_117 VDD VSS DCAP64
XFILLER_T_5_116 VDD VSS DCAP4
XFILLER_T_5_108 VDD VSS DCAP4
XFILLER_T_5_107 VDD VSS DCAP32
XFILLER_T_5_106 VDD VSS DCAP64
XFILLER_T_5_105 VDD VSS DCAP64
XFILLER_T_5_103 VDD VSS DCAP4
XFILLER_T_5_102 VDD VSS DCAP4
XFILLER_T_5_101 VDD VSS DCAP32
XFILLER_T_5_100 VDD VSS DCAP64
XFILLER_T_5_99 VDD VSS DCAP64
XFILLER_T_5_98 VDD VSS DCAP8
XFILLER_T_5_97 VDD VSS DCAP16
XFILLER_T_4_59 VDD VSS DCAP4
XFILLER_T_5_91 VDD VSS DCAP4
XFILLER_T_5_85 VDD VSS DCAP4
XFILLER_T_5_84 VDD VSS DCAP16
XFILLER_T_4_52 VDD VSS DCAP4
XFILLER_T_5_81 VDD VSS DCAP8
XFILLER_T_5_80 VDD VSS DCAP64
XFILLER_T_5_79 VDD VSS DCAP64
XFILLER_T_5_76 VDD VSS DCAP8
XFILLER_T_5_75 VDD VSS DCAP16
XFILLER_T_4_49 VDD VSS DCAP4
XFILLER_T_4_48 VDD VSS DCAP8
XFILLER_T_5_72 VDD VSS DCAP8
XFILLER_T_5_71 VDD VSS DCAP16
XFILLER_T_5_68 VDD VSS DCAP32
XFILLER_T_5_67 VDD VSS DCAP64
XFILLER_T_5_66 VDD VSS DCAP64
XFILLER_T_5_64 VDD VSS DCAP4
XFILLER_T_4_42 VDD VSS DCAP4
XFILLER_T_5_61 VDD VSS DCAP16
XFILLER_T_4_41 VDD VSS DCAP8
XFILLER_T_4_39 VDD VSS DCAP4
XFILLER_T_5_54 VDD VSS DCAP8
XFILLER_T_5_53 VDD VSS DCAP64
XFILLER_T_5_52 VDD VSS DCAP64
XFILLER_T_4_32 VDD VSS DCAP16
XFILLER_T_5_45 VDD VSS DCAP8
XFILLER_T_5_44 VDD VSS DCAP64
XFILLER_T_5_43 VDD VSS DCAP64
XFILLER_T_5_39 VDD VSS DCAP4
XFILLER_T_5_38 VDD VSS DCAP8
XFILLER_T_4_23 VDD VSS DCAP4
XFILLER_T_5_35 VDD VSS DCAP8
XFILLER_T_5_32 VDD VSS DCAP4
XFILLER_T_5_31 VDD VSS DCAP8
XFILLER_T_5_30 VDD VSS DCAP16
XFILLER_T_5_29 VDD VSS DCAP32
XFILLER_T_5_28 VDD VSS DCAP64
XFILLER_T_5_25 VDD VSS DCAP4
XFILLER_T_4_17 VDD VSS DCAP4
XFILLER_T_4_16 VDD VSS DCAP4
XFILLER_T_5_20 VDD VSS DCAP16
XFILLER_T_5_19 VDD VSS DCAP32
XFILLER_T_5_18 VDD VSS DCAP64
XFILLER_T_5_15 VDD VSS DCAP4
XFILLER_T_5_10 VDD VSS DCAP32
XFILLER_T_5_9 VDD VSS DCAP64
XFILLER_T_4_7 VDD VSS DCAP4
XFILLER_T_5_6 VDD VSS DCAP4
XFILLER_T_5_3 VDD VSS DCAP16
XFILLER_T_5_2 VDD VSS DCAP64
XFILLER_T_4_2 VDD VSS DCAP4
XFILLER_T_5_1 VDD VSS DCAP64
XFILLER_T_2_1076 VDD VSS DCAP4
XFILLER_T_2_1075 VDD VSS DCAP8
XFILLER_T_2_1073 VDD VSS DCAP4
XFILLER_T_2_1072 VDD VSS DCAP32
XFILLER_T_2_1071 VDD VSS DCAP64
XFILLER_T_2_1059 VDD VSS DCAP4
XFILLER_T_2_1058 VDD VSS DCAP8
XFILLER_T_2_1057 VDD VSS DCAP64
XFILLER_T_2_1055 VDD VSS DCAP8
XFILLER_T_2_1054 VDD VSS DCAP4
XFILLER_T_2_1049 VDD VSS DCAP16
XFILLER_T_2_1048 VDD VSS DCAP64
XFILLER_T_2_1043 VDD VSS DCAP4
XFILLER_T_2_1042 VDD VSS DCAP32
XFILLER_T_2_1040 VDD VSS DCAP4
XFILLER_T_2_1038 VDD VSS DCAP8
XFILLER_T_2_1037 VDD VSS DCAP16
XFILLER_T_2_1036 VDD VSS DCAP64
XFILLER_T_2_1033 VDD VSS DCAP4
XFILLER_T_2_1032 VDD VSS DCAP4
XFILLER_T_2_1026 VDD VSS DCAP8
XFILLER_T_2_1025 VDD VSS DCAP64
XFILLER_T_2_1023 VDD VSS DCAP4
XFILLER_T_2_1022 VDD VSS DCAP8
XFILLER_T_2_1019 VDD VSS DCAP4
XFILLER_T_2_1017 VDD VSS DCAP4
XFILLER_T_2_1016 VDD VSS DCAP16
XFILLER_T_2_1015 VDD VSS DCAP64
XFILLER_T_2_1012 VDD VSS DCAP4
XFILLER_T_2_1011 VDD VSS DCAP4
XFILLER_T_2_1010 VDD VSS DCAP64
XFILLER_T_2_1005 VDD VSS DCAP8
XFILLER_T_2_1004 VDD VSS DCAP64
XFILLER_T_2_1003 VDD VSS DCAP64
XFILLER_T_2_999 VDD VSS DCAP4
XFILLER_T_2_996 VDD VSS DCAP8
XFILLER_T_2_995 VDD VSS DCAP64
XFILLER_T_2_994 VDD VSS DCAP16
XFILLER_T_2_993 VDD VSS DCAP64
XFILLER_T_2_992 VDD VSS DCAP4
XFILLER_T_2_990 VDD VSS DCAP8
XFILLER_T_2_989 VDD VSS DCAP64
XFILLER_T_2_987 VDD VSS DCAP16
XFILLER_T_2_986 VDD VSS DCAP64
XFILLER_T_2_985 VDD VSS DCAP4
XFILLER_T_2_984 VDD VSS DCAP8
XFILLER_T_2_982 VDD VSS DCAP4
XFILLER_T_2_981 VDD VSS DCAP16
XFILLER_T_2_980 VDD VSS DCAP64
XFILLER_T_2_976 VDD VSS DCAP4
XFILLER_T_2_975 VDD VSS DCAP16
XFILLER_T_2_974 VDD VSS DCAP64
XFILLER_T_2_967 VDD VSS DCAP8
XFILLER_T_2_965 VDD VSS DCAP8
XFILLER_T_2_961 VDD VSS DCAP8
XFILLER_T_2_959 VDD VSS DCAP16
XFILLER_T_2_958 VDD VSS DCAP64
XFILLER_T_2_949 VDD VSS DCAP8
XFILLER_T_2_941 VDD VSS DCAP4
XFILLER_T_2_940 VDD VSS DCAP4
XFILLER_T_2_935 VDD VSS DCAP4
XFILLER_T_2_934 VDD VSS DCAP8
XFILLER_T_2_930 VDD VSS DCAP16
XFILLER_T_2_929 VDD VSS DCAP64
XFILLER_T_2_926 VDD VSS DCAP4
XFILLER_T_2_925 VDD VSS DCAP4
XFILLER_T_2_920 VDD VSS DCAP4
XFILLER_T_2_919 VDD VSS DCAP8
XFILLER_T_2_915 VDD VSS DCAP4
XFILLER_T_2_893 VDD VSS DCAP64
XFILLER_T_2_892 VDD VSS DCAP4
XFILLER_T_2_887 VDD VSS DCAP4
XFILLER_T_2_882 VDD VSS DCAP8
XFILLER_T_2_880 VDD VSS DCAP4
XFILLER_T_2_871 VDD VSS DCAP4
XFILLER_T_2_863 VDD VSS DCAP16
XFILLER_T_2_862 VDD VSS DCAP64
XFILLER_T_2_860 VDD VSS DCAP4
XFILLER_T_2_859 VDD VSS DCAP8
XFILLER_T_2_844 VDD VSS DCAP4
XFILLER_T_2_841 VDD VSS DCAP4
XFILLER_T_2_840 VDD VSS DCAP8
XFILLER_T_2_833 VDD VSS DCAP64
XFILLER_T_2_832 VDD VSS DCAP4
XFILLER_T_2_828 VDD VSS DCAP4
XFILLER_T_2_827 VDD VSS DCAP8
XFILLER_T_2_821 VDD VSS DCAP4
XFILLER_T_2_817 VDD VSS DCAP8
XFILLER_T_2_808 VDD VSS DCAP4
XFILLER_T_2_807 VDD VSS DCAP4
XFILLER_T_2_805 VDD VSS DCAP4
XFILLER_T_2_803 VDD VSS DCAP4
XFILLER_T_2_802 VDD VSS DCAP64
XFILLER_T_2_797 VDD VSS DCAP8
XFILLER_T_2_796 VDD VSS DCAP16
XFILLER_T_2_786 VDD VSS DCAP8
XFILLER_T_2_785 VDD VSS DCAP16
XFILLER_T_2_784 VDD VSS DCAP32
XFILLER_T_2_782 VDD VSS DCAP4
XFILLER_T_2_781 VDD VSS DCAP8
XFILLER_T_2_777 VDD VSS DCAP4
XFILLER_T_2_776 VDD VSS DCAP4
XFILLER_T_2_771 VDD VSS DCAP64
XFILLER_T_2_766 VDD VSS DCAP4
XFILLER_T_2_762 VDD VSS DCAP4
XFILLER_T_2_759 VDD VSS DCAP4
XFILLER_T_2_755 VDD VSS DCAP8
XFILLER_T_2_752 VDD VSS DCAP4
XFILLER_T_2_749 VDD VSS DCAP4
XFILLER_T_2_748 VDD VSS DCAP4
XFILLER_T_2_746 VDD VSS DCAP64
XFILLER_T_2_744 VDD VSS DCAP4
XFILLER_T_2_743 VDD VSS DCAP16
XFILLER_T_2_741 VDD VSS DCAP4
XFILLER_T_2_740 VDD VSS DCAP16
XFILLER_T_2_738 VDD VSS DCAP8
XFILLER_T_2_735 VDD VSS DCAP8
XFILLER_T_2_728 VDD VSS DCAP4
XFILLER_T_2_724 VDD VSS DCAP16
XFILLER_T_2_723 VDD VSS DCAP64
XFILLER_T_2_721 VDD VSS DCAP4
XFILLER_T_2_719 VDD VSS DCAP4
XFILLER_T_2_718 VDD VSS DCAP8
XFILLER_T_2_717 VDD VSS DCAP8
XFILLER_T_2_706 VDD VSS DCAP4
XFILLER_T_2_705 VDD VSS DCAP16
XFILLER_T_2_701 VDD VSS DCAP8
XFILLER_T_2_700 VDD VSS DCAP32
XFILLER_T_2_699 VDD VSS DCAP64
XFILLER_T_2_691 VDD VSS DCAP4
XFILLER_T_2_688 VDD VSS DCAP4
XFILLER_T_2_686 VDD VSS DCAP4
XFILLER_T_2_685 VDD VSS DCAP16
XFILLER_T_2_684 VDD VSS DCAP32
XFILLER_T_2_683 VDD VSS DCAP64
XFILLER_T_2_678 VDD VSS DCAP4
XFILLER_T_2_667 VDD VSS DCAP4
XFILLER_T_2_657 VDD VSS DCAP8
XFILLER_T_2_656 VDD VSS DCAP64
XFILLER_T_2_655 VDD VSS DCAP64
XFILLER_T_2_654 VDD VSS DCAP4
XFILLER_T_2_653 VDD VSS DCAP8
XFILLER_T_2_652 VDD VSS DCAP16
XFILLER_T_2_647 VDD VSS DCAP4
XFILLER_T_2_642 VDD VSS DCAP4
XFILLER_T_2_641 VDD VSS DCAP32
XFILLER_T_2_640 VDD VSS DCAP64
XFILLER_T_2_637 VDD VSS DCAP4
XFILLER_T_2_636 VDD VSS DCAP16
XFILLER_T_2_634 VDD VSS DCAP4
XFILLER_T_2_630 VDD VSS DCAP4
XFILLER_T_2_612 VDD VSS DCAP4
XFILLER_T_2_611 VDD VSS DCAP8
XFILLER_T_2_610 VDD VSS DCAP16
XFILLER_T_1_561 VDD VSS DCAP4
XFILLER_T_2_609 VDD VSS DCAP32
XFILLER_T_2_608 VDD VSS DCAP64
XFILLER_T_2_606 VDD VSS DCAP4
XFILLER_T_1_559 VDD VSS DCAP4
XFILLER_T_2_605 VDD VSS DCAP16
XFILLER_T_2_604 VDD VSS DCAP32
XFILLER_T_2_598 VDD VSS DCAP4
XFILLER_T_2_597 VDD VSS DCAP8
XFILLER_T_1_548 VDD VSS DCAP4
XFILLER_T_1_546 VDD VSS DCAP4
XFILLER_T_2_588 VDD VSS DCAP16
XFILLER_T_2_587 VDD VSS DCAP32
XFILLER_T_2_586 VDD VSS DCAP64
XFILLER_T_2_581 VDD VSS DCAP4
XFILLER_T_1_538 VDD VSS DCAP8
XFILLER_T_1_534 VDD VSS DCAP8
XFILLER_T_2_575 VDD VSS DCAP4
XFILLER_T_2_573 VDD VSS DCAP4
XFILLER_T_2_572 VDD VSS DCAP16
XFILLER_T_2_567 VDD VSS DCAP16
XFILLER_T_2_563 VDD VSS DCAP4
XFILLER_T_2_559 VDD VSS DCAP16
XFILLER_T_2_558 VDD VSS DCAP64
XFILLER_T_1_519 VDD VSS DCAP4
XFILLER_T_2_556 VDD VSS DCAP4
XFILLER_T_2_554 VDD VSS DCAP4
XFILLER_T_1_517 VDD VSS DCAP4
XFILLER_T_2_553 VDD VSS DCAP8
XFILLER_T_2_552 VDD VSS DCAP4
XFILLER_T_2_547 VDD VSS DCAP4
XFILLER_T_1_511 VDD VSS DCAP8
XFILLER_T_2_545 VDD VSS DCAP4
XFILLER_T_2_544 VDD VSS DCAP8
XFILLER_T_2_541 VDD VSS DCAP8
XFILLER_T_2_540 VDD VSS DCAP16
XFILLER_T_1_506 VDD VSS DCAP4
XFILLER_T_1_503 VDD VSS DCAP4
XFILLER_T_2_535 VDD VSS DCAP16
XFILLER_T_1_501 VDD VSS DCAP4
XFILLER_T_2_531 VDD VSS DCAP16
XFILLER_T_2_530 VDD VSS DCAP32
XFILLER_T_2_528 VDD VSS DCAP4
XFILLER_T_2_527 VDD VSS DCAP8
XFILLER_T_2_526 VDD VSS DCAP16
XFILLER_T_1_497 VDD VSS DCAP16
XFILLER_T_1_494 VDD VSS DCAP4
XFILLER_T_2_522 VDD VSS DCAP4
XFILLER_T_1_491 VDD VSS DCAP4
XFILLER_T_2_514 VDD VSS DCAP4
XFILLER_T_2_508 VDD VSS DCAP4
XFILLER_T_1_485 VDD VSS DCAP8
XFILLER_T_2_505 VDD VSS DCAP4
XFILLER_T_2_504 VDD VSS DCAP8
XFILLER_T_2_499 VDD VSS DCAP4
XFILLER_T_2_498 VDD VSS DCAP16
XFILLER_T_2_497 VDD VSS DCAP32
XFILLER_T_2_494 VDD VSS DCAP4
XFILLER_T_2_493 VDD VSS DCAP8
XFILLER_T_2_491 VDD VSS DCAP8
XFILLER_T_2_479 VDD VSS DCAP4
XFILLER_T_1_466 VDD VSS DCAP4
XFILLER_T_2_477 VDD VSS DCAP4
XFILLER_T_2_475 VDD VSS DCAP4
XFILLER_T_1_464 VDD VSS DCAP4
XFILLER_T_2_471 VDD VSS DCAP16
XFILLER_T_1_462 VDD VSS DCAP4
XFILLER_T_1_460 VDD VSS DCAP4
XFILLER_T_2_467 VDD VSS DCAP4
XFILLER_T_2_466 VDD VSS DCAP8
XFILLER_T_2_465 VDD VSS DCAP16
XFILLER_T_2_464 VDD VSS DCAP32
XFILLER_T_2_459 VDD VSS DCAP8
XFILLER_T_2_458 VDD VSS DCAP4
XFILLER_T_1_452 VDD VSS DCAP4
XFILLER_T_1_450 VDD VSS DCAP4
XFILLER_T_1_449 VDD VSS DCAP8
XFILLER_T_2_452 VDD VSS DCAP8
XFILLER_T_1_447 VDD VSS DCAP4
XFILLER_T_2_447 VDD VSS DCAP4
XFILLER_T_1_440 VDD VSS DCAP16
XFILLER_T_1_438 VDD VSS DCAP4
XFILLER_T_2_440 VDD VSS DCAP4
XFILLER_T_1_436 VDD VSS DCAP16
XFILLER_T_2_439 VDD VSS DCAP16
XFILLER_T_2_438 VDD VSS DCAP32
XFILLER_T_2_435 VDD VSS DCAP8
XFILLER_T_2_431 VDD VSS DCAP8
XFILLER_T_1_432 VDD VSS DCAP4
XFILLER_T_1_431 VDD VSS DCAP8
XFILLER_T_2_430 VDD VSS DCAP4
XFILLER_T_1_429 VDD VSS DCAP4
XFILLER_T_2_428 VDD VSS DCAP8
XFILLER_T_1_427 VDD VSS DCAP4
XFILLER_T_1_425 VDD VSS DCAP8
XFILLER_T_1_421 VDD VSS DCAP4
XFILLER_T_1_417 VDD VSS DCAP4
XFILLER_T_1_416 VDD VSS DCAP4
XFILLER_T_1_415 VDD VSS DCAP4
XFILLER_T_1_413 VDD VSS DCAP8
XFILLER_T_2_412 VDD VSS DCAP4
XFILLER_T_2_410 VDD VSS DCAP4
XFILLER_T_2_409 VDD VSS DCAP16
XFILLER_T_2_408 VDD VSS DCAP32
XFILLER_T_2_405 VDD VSS DCAP4
XFILLER_T_2_404 VDD VSS DCAP16
XFILLER_T_1_403 VDD VSS DCAP4
XFILLER_T_2_391 VDD VSS DCAP4
XFILLER_T_2_390 VDD VSS DCAP16
XFILLER_T_2_389 VDD VSS DCAP32
XFILLER_T_2_387 VDD VSS DCAP4
XFILLER_T_2_383 VDD VSS DCAP4
XFILLER_T_1_392 VDD VSS DCAP4
XFILLER_T_2_380 VDD VSS DCAP4
XFILLER_T_1_389 VDD VSS DCAP4
XFILLER_T_1_387 VDD VSS DCAP4
XFILLER_T_2_365 VDD VSS DCAP4
XFILLER_T_2_363 VDD VSS DCAP4
XFILLER_T_2_362 VDD VSS DCAP8
XFILLER_T_1_380 VDD VSS DCAP4
XFILLER_T_2_361 VDD VSS DCAP16
XFILLER_T_2_360 VDD VSS DCAP32
XFILLER_T_2_358 VDD VSS DCAP4
XFILLER_T_2_357 VDD VSS DCAP8
XFILLER_T_1_376 VDD VSS DCAP4
XFILLER_T_2_355 VDD VSS DCAP16
XFILLER_T_2_353 VDD VSS DCAP4
XFILLER_T_1_373 VDD VSS DCAP4
XFILLER_T_2_352 VDD VSS DCAP4
XFILLER_T_2_351 VDD VSS DCAP8
XFILLER_T_2_350 VDD VSS DCAP16
XFILLER_T_1_368 VDD VSS DCAP4
XFILLER_T_2_346 VDD VSS DCAP4
XFILLER_T_2_344 VDD VSS DCAP4
XFILLER_T_2_342 VDD VSS DCAP4
XFILLER_T_2_341 VDD VSS DCAP8
XFILLER_T_1_361 VDD VSS DCAP4
XFILLER_T_2_331 VDD VSS DCAP4
XFILLER_T_2_330 VDD VSS DCAP8
XFILLER_T_2_329 VDD VSS DCAP32
XFILLER_T_2_327 VDD VSS DCAP4
XFILLER_T_2_326 VDD VSS DCAP16
XFILLER_T_1_355 VDD VSS DCAP4
XFILLER_T_2_321 VDD VSS DCAP8
XFILLER_T_1_349 VDD VSS DCAP4
XFILLER_T_2_315 VDD VSS DCAP4
XFILLER_T_1_334 VDD VSS DCAP4
XFILLER_T_2_307 VDD VSS DCAP32
XFILLER_T_1_326 VDD VSS DCAP4
XFILLER_T_1_323 VDD VSS DCAP4
XFILLER_T_2_294 VDD VSS DCAP4
XFILLER_T_2_293 VDD VSS DCAP4
XFILLER_T_1_319 VDD VSS DCAP4
XFILLER_T_1_308 VDD VSS DCAP4
XFILLER_T_2_278 VDD VSS DCAP16
XFILLER_T_2_277 VDD VSS DCAP8
XFILLER_T_2_276 VDD VSS DCAP32
XFILLER_T_1_304 VDD VSS DCAP4
XFILLER_T_1_302 VDD VSS DCAP4
XFILLER_T_2_268 VDD VSS DCAP4
XFILLER_T_2_267 VDD VSS DCAP8
XFILLER_T_1_292 VDD VSS DCAP8
XFILLER_T_2_264 VDD VSS DCAP4
XFILLER_T_1_289 VDD VSS DCAP16
XFILLER_T_2_262 VDD VSS DCAP8
XFILLER_T_2_257 VDD VSS DCAP4
XFILLER_T_2_254 VDD VSS DCAP8
XFILLER_T_2_253 VDD VSS DCAP32
XFILLER_T_2_252 VDD VSS DCAP4
XFILLER_T_2_251 VDD VSS DCAP8
XFILLER_T_2_250 VDD VSS DCAP16
XFILLER_T_2_246 VDD VSS DCAP8
XFILLER_T_2_243 VDD VSS DCAP4
XFILLER_T_2_242 VDD VSS DCAP4
XFILLER_T_2_240 VDD VSS DCAP8
XFILLER_T_1_266 VDD VSS DCAP4
XFILLER_T_2_233 VDD VSS DCAP16
XFILLER_T_2_232 VDD VSS DCAP32
XFILLER_T_1_264 VDD VSS DCAP8
XFILLER_T_2_229 VDD VSS DCAP8
XFILLER_T_1_261 VDD VSS DCAP4
XFILLER_T_2_222 VDD VSS DCAP8
XFILLER_T_1_255 VDD VSS DCAP4
XFILLER_T_2_221 VDD VSS DCAP4
XFILLER_T_2_213 VDD VSS DCAP8
XFILLER_T_1_246 VDD VSS DCAP8
XFILLER_T_1_245 VDD VSS DCAP16
XFILLER_T_1_244 VDD VSS DCAP4
XFILLER_T_1_243 VDD VSS DCAP8
XFILLER_T_2_204 VDD VSS DCAP8
XFILLER_T_2_203 VDD VSS DCAP16
XFILLER_T_2_202 VDD VSS DCAP4
XFILLER_T_1_234 VDD VSS DCAP4
XFILLER_T_1_233 VDD VSS DCAP8
XFILLER_T_1_228 VDD VSS DCAP8
XFILLER_T_2_192 VDD VSS DCAP4
XFILLER_T_2_186 VDD VSS DCAP4
XFILLER_T_1_221 VDD VSS DCAP16
XFILLER_T_2_180 VDD VSS DCAP8
XFILLER_T_2_175 VDD VSS DCAP4
XFILLER_T_2_174 VDD VSS DCAP8
XFILLER_T_2_172 VDD VSS DCAP4
XFILLER_T_1_209 VDD VSS DCAP4
XFILLER_T_1_206 VDD VSS DCAP8
XFILLER_T_2_167 VDD VSS DCAP4
XFILLER_T_1_205 VDD VSS DCAP4
XFILLER_T_1_199 VDD VSS DCAP4
XFILLER_T_1_195 VDD VSS DCAP4
XFILLER_T_2_158 VDD VSS DCAP4
XFILLER_T_1_194 VDD VSS DCAP8
XFILLER_T_1_192 VDD VSS DCAP4
XFILLER_T_1_191 VDD VSS DCAP16
XFILLER_T_1_188 VDD VSS DCAP4
XFILLER_T_2_150 VDD VSS DCAP8
XFILLER_T_2_145 VDD VSS DCAP8
XFILLER_T_1_181 VDD VSS DCAP4
XFILLER_T_2_141 VDD VSS DCAP8
XFILLER_T_2_140 VDD VSS DCAP16
XFILLER_T_1_175 VDD VSS DCAP4
XFILLER_T_2_134 VDD VSS DCAP4
XFILLER_T_1_169 VDD VSS DCAP4
XFILLER_T_1_168 VDD VSS DCAP4
XFILLER_T_1_164 VDD VSS DCAP4
XFILLER_T_1_163 VDD VSS DCAP4
XFILLER_T_2_127 VDD VSS DCAP4
XFILLER_T_2_124 VDD VSS DCAP4
XFILLER_T_2_122 VDD VSS DCAP4
XFILLER_T_2_120 VDD VSS DCAP4
XFILLER_T_1_152 VDD VSS DCAP8
XFILLER_T_1_149 VDD VSS DCAP8
XFILLER_T_2_109 VDD VSS DCAP4
XFILLER_T_2_108 VDD VSS DCAP8
XFILLER_T_1_141 VDD VSS DCAP4
XFILLER_T_1_136 VDD VSS DCAP16
XFILLER_T_2_102 VDD VSS DCAP4
XFILLER_T_2_100 VDD VSS DCAP4
XFILLER_T_1_132 VDD VSS DCAP8
XFILLER_T_2_99 VDD VSS DCAP4
XFILLER_T_1_130 VDD VSS DCAP32
XFILLER_T_2_96 VDD VSS DCAP4
XFILLER_T_1_121 VDD VSS DCAP8
XFILLER_T_2_88 VDD VSS DCAP4
XFILLER_T_1_120 VDD VSS DCAP32
XFILLER_T_1_116 VDD VSS DCAP4
XFILLER_T_1_115 VDD VSS DCAP16
XFILLER_T_1_113 VDD VSS DCAP8
XFILLER_T_2_83 VDD VSS DCAP4
XFILLER_T_1_112 VDD VSS DCAP8
XFILLER_T_1_109 VDD VSS DCAP8
XFILLER_T_1_108 VDD VSS DCAP4
XFILLER_T_1_105 VDD VSS DCAP4
XFILLER_T_1_104 VDD VSS DCAP4
XFILLER_T_2_76 VDD VSS DCAP4
XFILLER_T_1_103 VDD VSS DCAP16
XFILLER_T_1_102 VDD VSS DCAP32
XFILLER_T_2_73 VDD VSS DCAP4
XFILLER_T_1_98 VDD VSS DCAP4
XFILLER_T_2_71 VDD VSS DCAP16
XFILLER_T_2_69 VDD VSS DCAP8
XFILLER_T_1_94 VDD VSS DCAP8
XFILLER_T_2_66 VDD VSS DCAP8
XFILLER_T_2_65 VDD VSS DCAP4
XFILLER_T_1_90 VDD VSS DCAP16
XFILLER_T_1_89 VDD VSS DCAP64
XFILLER_T_1_88 VDD VSS DCAP64
XFILLER_T_2_59 VDD VSS DCAP4
XFILLER_T_1_82 VDD VSS DCAP16
XFILLER_T_2_58 VDD VSS DCAP4
XFILLER_T_1_81 VDD VSS DCAP4
XFILLER_T_2_57 VDD VSS DCAP8
XFILLER_T_1_77 VDD VSS DCAP16
XFILLER_T_2_53 VDD VSS DCAP4
XFILLER_T_1_69 VDD VSS DCAP8
XFILLER_T_2_46 VDD VSS DCAP8
XFILLER_T_1_68 VDD VSS DCAP16
XFILLER_T_1_67 VDD VSS DCAP64
XFILLER_T_1_66 VDD VSS DCAP64
XFILLER_T_1_60 VDD VSS DCAP4
XFILLER_T_1_59 VDD VSS DCAP4
XFILLER_T_1_58 VDD VSS DCAP8
XFILLER_T_2_33 VDD VSS DCAP4
XFILLER_T_1_46 VDD VSS DCAP4
XFILLER_T_1_45 VDD VSS DCAP16
XFILLER_T_1_44 VDD VSS DCAP32
XFILLER_T_1_43 VDD VSS DCAP64
XFILLER_T_1_42 VDD VSS DCAP64
XFILLER_T_2_27 VDD VSS DCAP4
XFILLER_T_1_39 VDD VSS DCAP4
XFILLER_T_2_26 VDD VSS DCAP16
XFILLER_T_1_38 VDD VSS DCAP8
XFILLER_T_1_36 VDD VSS DCAP8
XFILLER_T_1_35 VDD VSS DCAP16
XFILLER_T_1_33 VDD VSS DCAP4
XFILLER_T_1_32 VDD VSS DCAP64
XFILLER_T_1_30 VDD VSS DCAP8
XFILLER_T_2_21 VDD VSS DCAP4
XFILLER_T_2_20 VDD VSS DCAP4
XFILLER_T_2_19 VDD VSS DCAP8
XFILLER_T_2_18 VDD VSS DCAP16
XFILLER_T_1_23 VDD VSS DCAP4
XFILLER_T_1_21 VDD VSS DCAP4
XFILLER_T_1_19 VDD VSS DCAP4
XFILLER_T_1_18 VDD VSS DCAP16
XFILLER_T_1_17 VDD VSS DCAP64
XFILLER_T_1_16 VDD VSS DCAP64
XFILLER_T_1_15 VDD VSS DCAP64
XFILLER_T_1_12 VDD VSS DCAP8
XFILLER_T_1_11 VDD VSS DCAP64
XFILLER_T_2_9 VDD VSS DCAP16
XFILLER_T_1_10 VDD VSS DCAP64
XFILLER_T_1_6 VDD VSS DCAP32
XFILLER_T_1_4 VDD VSS DCAP32
XFILLER_T_1_3 VDD VSS DCAP64
XFILLER_T_1_2 VDD VSS DCAP64
XFILLER_T_1_1 VDD VSS DCAP64
.ENDS
.GLOBAL VSS
